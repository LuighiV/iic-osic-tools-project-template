* NGSPICE file created from DAC5_pex.ext - technology: sky130A

.subckt DAC5_pex avdd avss b0 b1 b2 b3 b4 vrefh vrefl vout
X0 DAC4_0.DAC3_1.DAC2_0.sw_0.vin1 DAC4_0.DAC3_1.DAC2_0.sw_0.XM8.G DAC4_0.DAC3_1.DAC2_0.sw_2.vin2 avss.t111 sky130_fd_pr__nfet_01v8 ad=0.145 pd=1.58 as=0.145 ps=1.58 w=0.5 l=0.15
X1 DAC4_0.DAC3_1.DAC2_0.sw_2.vin1 DAC4_0.DAC3_1.DAC2_0.sw_1.XM6.G.t2 DAC4_0.DAC3_1.DAC2_0.sw_1.vin2 avss.t151 sky130_fd_pr__nfet_01v8 ad=0.145 pd=1.58 as=0.145 ps=1.58 w=0.5 l=0.15
X2 DAC4_0.DAC3_1.sw_0.vin1 DAC4_0.DAC3_1.DAC2_0.sw_2.XM6.G.t4 DAC4_0.DAC3_1.DAC2_0.sw_2.vin1 avdd.t127 sky130_fd_pr__pfet_01v8 ad=0.145 pd=1.58 as=0.145 ps=1.58 w=0.5 l=0.15
R0 vrefl DAC4_1.DAC3_1.DAC2_1.sw_0.vin1 sky130_fd_pr__res_generic_l1 w=1 l=3.75
X3 DAC4_0.DAC3_0.DAC2_0.sw_0.XM6.G.t1 b0 avdd.t84 avdd.t83 sky130_fd_pr__pfet_01v8 ad=0.145 pd=1.58 as=0.145 ps=1.58 w=0.5 l=0.15
X4 DAC4_1.DAC3_0.DAC2_1.sw_2.vin1 DAC4_1.DAC3_0.DAC2_1.sw_2.XM6.G DAC4_1.DAC3_0.sw_0.vin2 avdd.t153 sky130_fd_pr__pfet_01v8 ad=0.145 pd=1.58 as=0.145 ps=1.58 w=0.5 l=0.15
X5 DAC4_1.DAC3_0.DAC2_1.sw_1.vin2 DAC4_1.DAC3_0.DAC2_1.sw_1.XM6.G DAC4_1.DAC3_0.DAC2_1.sw_2.vin1 avss.t37 sky130_fd_pr__nfet_01v8 ad=0.145 pd=1.58 as=0.145 ps=1.58 w=0.5 l=0.15
X6 DAC4_0.DAC3_1.sw_0.XM6.G.t0 b2 avss.t161 avss.t160 sky130_fd_pr__nfet_01v8 ad=0.145 pd=1.58 as=0.145 ps=1.58 w=0.5 l=0.15
X7 DAC4_0.DAC3_0.DAC2_1.sw_0.XM8.G DAC4_0.DAC3_0.DAC2_1.sw_0.XM6.G.t3 avss.t150 avss.t149 sky130_fd_pr__nfet_01v8 ad=0.145 pd=1.58 as=0.145 ps=1.58 w=0.5 l=0.15
X8 DAC4_0.DAC3_1.DAC2_1.sw_2.XM6.G.t1 b1 avdd.t122 avdd.t121 sky130_fd_pr__pfet_01v8 ad=0.145 pd=1.58 as=0.145 ps=1.58 w=0.5 l=0.15
R1 DAC4_1.DAC3_1.DAC2_1.sw_0.vin1 DAC4_1.DAC3_1.DAC2_1.sw_1.vin2 sky130_fd_pr__res_generic_l1 w=1 l=3.75
X9 DAC4_0.DAC3_1.DAC2_1.sw_0.XM6.G.t0 b0 avss.t109 avss.t108 sky130_fd_pr__nfet_01v8 ad=0.145 pd=1.58 as=0.145 ps=1.58 w=0.5 l=0.15
X10 DAC4_1.sw_0.vin2 DAC4_1.DAC3_1.sw_0.XM8.G DAC4_1.DAC3_1.sw_0.vin1 avss.t29 sky130_fd_pr__nfet_01v8 ad=0.145 pd=1.58 as=0.145 ps=1.58 w=0.5 l=0.15
X11 avdd.t155 DAC4_1.DAC3_0.DAC2_1.sw_2.XM6.G DAC4_1.DAC3_0.DAC2_1.sw_2.XM8.G avdd.t154 sky130_fd_pr__pfet_01v8 ad=0.145 pd=1.58 as=0.145 ps=1.58 w=0.5 l=0.15
X12 avdd.t78 b0 DAC4_1.DAC3_1.DAC2_0.sw_1.XM6.G avdd.t77 sky130_fd_pr__pfet_01v8 ad=0.145 pd=1.58 as=0.145 ps=1.58 w=0.5 l=0.15
X13 DAC4_0.DAC3_1.DAC2_1.sw_0.vin1 DAC4_0.DAC3_1.DAC2_1.sw_0.XM8.G DAC4_0.DAC3_1.DAC2_1.sw_2.vin2 avss.t167 sky130_fd_pr__nfet_01v8 ad=0.145 pd=1.58 as=0.145 ps=1.58 w=0.5 l=0.15
X14 DAC4_0.DAC3_1.DAC2_1.sw_1.XM8.G DAC4_0.DAC3_1.DAC2_1.sw_1.XM6.G.t3 avss.t63 avss.t62 sky130_fd_pr__nfet_01v8 ad=0.145 pd=1.58 as=0.145 ps=1.58 w=0.5 l=0.15
X15 DAC4_0.sw_0.XM8.G DAC4_0.sw_0.XM6.G.t5 avdd.t8 avdd.t7 sky130_fd_pr__pfet_01v8 ad=0.145 pd=1.58 as=0.145 ps=1.58 w=0.5 l=0.15
X16 DAC4_0.DAC3_1.DAC2_0.sw_0.XM6.G.t1 b0 avdd.t98 avdd.t97 sky130_fd_pr__pfet_01v8 ad=0.145 pd=1.58 as=0.145 ps=1.58 w=0.5 l=0.15
X17 DAC4_0.DAC3_1.DAC2_0.sw_1.vin2 DAC4_0.DAC3_1.DAC2_0.sw_1.XM8.G DAC4_0.DAC3_1.DAC2_0.sw_2.vin1 avdd.t49 sky130_fd_pr__pfet_01v8 ad=0.145 pd=1.58 as=0.145 ps=1.58 w=0.5 l=0.15
R2 DAC4_1.DAC3_1.DAC2_1.sw_1.vin2 DAC4_1.DAC3_1.DAC2_1.sw_1.vin1 sky130_fd_pr__res_generic_l1 w=1 l=3.75
X18 DAC4_1.DAC3_1.DAC2_0.sw_2.vin1 DAC4_1.DAC3_1.DAC2_0.sw_1.XM8.G DAC4_1.DAC3_1.DAC2_0.sw_1.vin1 avss.t170 sky130_fd_pr__nfet_01v8 ad=0.145 pd=1.58 as=0.145 ps=1.58 w=0.5 l=0.15
X19 DAC4_0.DAC3_0.DAC2_1.sw_2.vin2 DAC4_0.DAC3_0.DAC2_1.sw_0.XM6.G.t4 DAC4_0.DAC3_0.DAC2_1.sw_0.vin1 avdd.t46 sky130_fd_pr__pfet_01v8 ad=0.145 pd=1.58 as=0.145 ps=1.58 w=0.5 l=0.15
X20 DAC4_0.DAC3_0.DAC2_0.sw_2.vin2 DAC4_0.DAC3_0.DAC2_0.sw_2.XM8.G DAC4_0.DAC3_0.sw_0.vin1 avdd.t1 sky130_fd_pr__pfet_01v8 ad=0.145 pd=1.58 as=0.145 ps=1.58 w=0.5 l=0.15
X21 sw_0.vin1 DAC4_0.sw_0.XM6.G.t4 DAC4_0.sw_0.vin1 avdd.t139 sky130_fd_pr__pfet_01v8 ad=0.145 pd=1.58 as=0.145 ps=1.58 w=0.5 l=0.15
X22 avss.t83 b0 DAC4_1.DAC3_0.DAC2_1.sw_0.XM6.G avss.t82 sky130_fd_pr__nfet_01v8 ad=0.145 pd=1.58 as=0.145 ps=1.58 w=0.5 l=0.15
X23 DAC4_0.DAC3_1.DAC2_0.sw_2.vin1 DAC4_0.DAC3_1.DAC2_0.sw_2.XM8.G DAC4_0.DAC3_1.sw_0.vin1 avss.t35 sky130_fd_pr__nfet_01v8 ad=0.145 pd=1.58 as=0.145 ps=1.58 w=0.5 l=0.15
R3 DAC4_0.DAC3_1.DAC2_1.sw_1.vin2 DAC4_0.DAC3_1.DAC2_1.sw_0.vin1 sky130_fd_pr__res_generic_l1 w=1 l=3.75
X24 DAC4_0.DAC3_1.DAC2_1.sw_2.vin1 DAC4_0.DAC3_1.DAC2_1.sw_1.XM6.G.t4 DAC4_0.DAC3_1.DAC2_1.sw_1.vin1 avdd.t0 sky130_fd_pr__pfet_01v8 ad=0.145 pd=1.58 as=0.145 ps=1.58 w=0.5 l=0.15
X25 avss.t19 DAC4_1.DAC3_1.DAC2_0.sw_1.XM6.G DAC4_1.DAC3_1.DAC2_0.sw_1.XM8.G avss.t18 sky130_fd_pr__nfet_01v8 ad=0.145 pd=1.58 as=0.145 ps=1.58 w=0.5 l=0.15
R4 DAC4_1.DAC3_1.DAC2_1.sw_1.vin1 DAC4_1.DAC3_1.DAC2_1.vrefh sky130_fd_pr__res_generic_l1 w=1 l=3.75
X26 avdd.t82 b0 DAC4_1.DAC3_1.DAC2_1.sw_0.XM6.G avdd.t81 sky130_fd_pr__pfet_01v8 ad=0.145 pd=1.58 as=0.145 ps=1.58 w=0.5 l=0.15
X27 DAC4_0.DAC3_0.DAC2_1.sw_1.XM6.G.t0 b0 avss.t97 avss.t96 sky130_fd_pr__nfet_01v8 ad=0.145 pd=1.58 as=0.145 ps=1.58 w=0.5 l=0.15
X28 DAC4_1.DAC3_1.DAC2_0.sw_0.vin1 DAC4_1.DAC3_1.DAC2_0.sw_0.XM6.G DAC4_1.DAC3_1.DAC2_0.sw_2.vin2 avdd.t12 sky130_fd_pr__pfet_01v8 ad=0.145 pd=1.58 as=0.145 ps=1.58 w=0.5 l=0.15
X29 DAC4_0.DAC3_0.DAC2_1.sw_2.XM8.G DAC4_0.DAC3_0.DAC2_1.sw_2.XM6.G.t3 avss.t145 avss.t144 sky130_fd_pr__nfet_01v8 ad=0.145 pd=1.58 as=0.145 ps=1.58 w=0.5 l=0.15
R5 DAC4_0.DAC3_1.vrefh DAC4_0.DAC3_1.DAC2_0.sw_1.vin1 sky130_fd_pr__res_generic_l1 w=1 l=3.75
R6 DAC4_1.DAC3_0.DAC2_1.vrefh DAC4_1.DAC3_0.DAC2_0.sw_0.vin1 sky130_fd_pr__res_generic_l1 w=1 l=3.75
X30 avss.t67 DAC4_1.DAC3_1.DAC2_1.sw_0.XM6.G DAC4_1.DAC3_1.DAC2_1.sw_0.XM8.G avss.t66 sky130_fd_pr__nfet_01v8 ad=0.145 pd=1.58 as=0.145 ps=1.58 w=0.5 l=0.15
X31 DAC4_1.DAC3_1.DAC2_0.sw_2.vin1 DAC4_1.DAC3_1.DAC2_0.sw_2.XM6.G DAC4_1.DAC3_1.sw_0.vin1 avdd.t133 sky130_fd_pr__pfet_01v8 ad=0.145 pd=1.58 as=0.145 ps=1.58 w=0.5 l=0.15
X32 avss.t173 DAC4_1.sw_0.XM6.G DAC4_1.sw_0.XM8.G avss.t172 sky130_fd_pr__nfet_01v8 ad=0.145 pd=1.58 as=0.145 ps=1.58 w=0.5 l=0.15
X33 avdd.t169 DAC4_1.sw_0.XM6.G DAC4_1.sw_0.XM8.G avdd.t168 sky130_fd_pr__pfet_01v8 ad=0.145 pd=1.58 as=0.145 ps=1.58 w=0.5 l=0.15
X34 avss.t101 b0 DAC4_1.DAC3_0.DAC2_0.sw_1.XM6.G avss.t100 sky130_fd_pr__nfet_01v8 ad=0.145 pd=1.58 as=0.145 ps=1.58 w=0.5 l=0.15
R7 DAC4_1.DAC3_1.DAC2_0.sw_0.vin1 DAC4_1.DAC3_1.DAC2_0.sw_1.vin2 sky130_fd_pr__res_generic_l1 w=1 l=3.75
X35 DAC4_0.DAC3_1.DAC2_1.sw_2.vin2 DAC4_0.DAC3_1.DAC2_1.sw_0.XM6.G.t2 DAC4_1.vrefh avss.t60 sky130_fd_pr__nfet_01v8 ad=0.145 pd=1.58 as=0.145 ps=1.58 w=0.5 l=0.15
X36 avdd.t45 DAC4_1.DAC3_0.DAC2_0.sw_0.XM6.G DAC4_1.DAC3_0.DAC2_0.sw_0.XM8.G avdd.t44 sky130_fd_pr__pfet_01v8 ad=0.145 pd=1.58 as=0.145 ps=1.58 w=0.5 l=0.15
X37 DAC4_0.DAC3_0.DAC2_0.sw_2.vin1 DAC4_0.DAC3_0.DAC2_0.sw_1.XM6.G.t4 DAC4_0.DAC3_0.DAC2_0.sw_1.vin1 avdd.t72 sky130_fd_pr__pfet_01v8 ad=0.145 pd=1.58 as=0.145 ps=1.58 w=0.5 l=0.15
X38 DAC4_0.DAC3_0.sw_0.XM6.G.t1 b2 avdd.t142 avdd.t141 sky130_fd_pr__pfet_01v8 ad=0.145 pd=1.58 as=0.145 ps=1.58 w=0.5 l=0.15
X39 DAC4_1.DAC3_0.DAC2_1.vrefh DAC4_1.DAC3_0.DAC2_0.sw_0.XM6.G DAC4_1.DAC3_0.DAC2_0.sw_2.vin2 avss.t50 sky130_fd_pr__nfet_01v8 ad=0.145 pd=1.58 as=0.145 ps=1.58 w=0.5 l=0.15
X40 DAC4_1.DAC3_1.DAC2_1.sw_2.vin1 DAC4_1.DAC3_1.DAC2_1.sw_2.XM6.G DAC4_1.DAC3_1.sw_0.vin2 avdd.t2 sky130_fd_pr__pfet_01v8 ad=0.145 pd=1.58 as=0.145 ps=1.58 w=0.5 l=0.15
X41 DAC4_0.DAC3_0.DAC2_0.sw_0.XM8.G DAC4_0.DAC3_0.DAC2_0.sw_0.XM6.G.t3 avss.t59 avss.t58 sky130_fd_pr__nfet_01v8 ad=0.145 pd=1.58 as=0.145 ps=1.58 w=0.5 l=0.15
X42 DAC4_0.DAC3_0.DAC2_1.sw_0.vin1 DAC4_0.DAC3_0.DAC2_1.sw_0.XM8.G DAC4_0.DAC3_0.DAC2_1.sw_2.vin2 avss.t30 sky130_fd_pr__nfet_01v8 ad=0.145 pd=1.58 as=0.145 ps=1.58 w=0.5 l=0.15
R8 DAC4_1.DAC3_0.DAC2_0.sw_0.vin1 DAC4_1.DAC3_0.DAC2_0.sw_1.vin2 sky130_fd_pr__res_generic_l1 w=1 l=3.75
R9 DAC4_0.DAC3_1.DAC2_0.sw_1.vin1 DAC4_0.DAC3_1.DAC2_0.sw_1.vin2 sky130_fd_pr__res_generic_l1 w=1 l=3.75
X43 avdd.t112 b1 DAC4_1.DAC3_1.DAC2_1.sw_2.XM6.G avdd.t111 sky130_fd_pr__pfet_01v8 ad=0.145 pd=1.58 as=0.145 ps=1.58 w=0.5 l=0.15
X44 avss.t76 DAC4_1.DAC3_1.sw_0.XM6.G DAC4_1.DAC3_1.sw_0.XM8.G avss.t75 sky130_fd_pr__nfet_01v8 ad=0.145 pd=1.58 as=0.145 ps=1.58 w=0.5 l=0.15
X45 DAC4_0.DAC3_1.DAC2_0.sw_2.vin2 DAC4_0.DAC3_1.DAC2_0.sw_0.XM6.G.t4 DAC4_0.DAC3_1.DAC2_0.sw_0.vin1 avdd.t165 sky130_fd_pr__pfet_01v8 ad=0.145 pd=1.58 as=0.145 ps=1.58 w=0.5 l=0.15
R10 DAC4_1.DAC3_1.DAC2_0.sw_1.vin2 DAC4_1.DAC3_1.DAC2_0.sw_1.vin1 sky130_fd_pr__res_generic_l1 w=1 l=3.75
X46 avss.t155 b2 DAC4_1.DAC3_0.sw_0.XM6.G avss.t154 sky130_fd_pr__nfet_01v8 ad=0.145 pd=1.58 as=0.145 ps=1.58 w=0.5 l=0.15
X47 DAC4_1.DAC3_1.DAC2_0.sw_2.vin2 DAC4_1.DAC3_1.DAC2_0.sw_2.XM6.G DAC4_1.DAC3_1.sw_0.vin1 avss.t141 sky130_fd_pr__nfet_01v8 ad=0.145 pd=1.58 as=0.145 ps=1.58 w=0.5 l=0.15
X48 DAC4_0.DAC3_1.DAC2_0.sw_2.XM6.G.t0 b1 avss.t129 avss.t128 sky130_fd_pr__nfet_01v8 ad=0.145 pd=1.58 as=0.145 ps=1.58 w=0.5 l=0.15
X49 avdd.t148 b2 DAC4_1.DAC3_0.sw_0.XM6.G avdd.t147 sky130_fd_pr__pfet_01v8 ad=0.145 pd=1.58 as=0.145 ps=1.58 w=0.5 l=0.15
R11 DAC4_0.DAC3_1.DAC2_0.sw_1.vin2 DAC4_0.DAC3_1.DAC2_0.sw_0.vin1 sky130_fd_pr__res_generic_l1 w=1 l=3.75
X50 DAC4_0.DAC3_1.DAC2_1.sw_1.vin1 DAC4_0.DAC3_1.DAC2_1.sw_1.XM8.G DAC4_0.DAC3_1.DAC2_1.sw_2.vin1 avss.t33 sky130_fd_pr__nfet_01v8 ad=0.145 pd=1.58 as=0.145 ps=1.58 w=0.5 l=0.15
X51 DAC4_0.DAC3_0.DAC2_0.sw_1.XM6.G.t1 b0 avdd.t80 avdd.t79 sky130_fd_pr__pfet_01v8 ad=0.145 pd=1.58 as=0.145 ps=1.58 w=0.5 l=0.15
X52 avdd.t66 DAC4_1.DAC3_1.DAC2_1.sw_1.XM6.G DAC4_1.DAC3_1.DAC2_1.sw_1.XM8.G avdd.t65 sky130_fd_pr__pfet_01v8 ad=0.145 pd=1.58 as=0.145 ps=1.58 w=0.5 l=0.15
R12 DAC4_1.DAC3_1.DAC2_0.sw_1.vin1 DAC4_1.DAC3_1.vrefh sky130_fd_pr__res_generic_l1 w=1 l=3.75
X53 DAC4_1.DAC3_0.DAC2_0.sw_2.vin1 DAC4_1.DAC3_0.DAC2_0.sw_2.XM6.G DAC4_1.DAC3_0.sw_0.vin1 avdd.t172 sky130_fd_pr__pfet_01v8 ad=0.145 pd=1.58 as=0.145 ps=1.58 w=0.5 l=0.15
X54 DAC4_1.DAC3_0.DAC2_1.sw_0.vin1 DAC4_1.DAC3_0.DAC2_1.sw_0.XM6.G DAC4_1.DAC3_0.DAC2_1.sw_2.vin2 avdd.t19 sky130_fd_pr__pfet_01v8 ad=0.145 pd=1.58 as=0.145 ps=1.58 w=0.5 l=0.15
X55 DAC4_0.sw_0.vin2 DAC4_0.DAC3_1.sw_0.XM6.G.t4 DAC4_0.DAC3_1.sw_0.vin1 avdd.t164 sky130_fd_pr__pfet_01v8 ad=0.145 pd=1.58 as=0.145 ps=1.58 w=0.5 l=0.15
X56 DAC4_1.DAC3_1.DAC2_1.sw_2.vin2 DAC4_1.DAC3_1.DAC2_1.sw_0.XM8.G vrefl avdd.t138 sky130_fd_pr__pfet_01v8 ad=0.145 pd=1.58 as=0.145 ps=1.58 w=0.5 l=0.15
X57 DAC4_0.DAC3_0.DAC2_1.sw_2.vin1 DAC4_0.DAC3_0.DAC2_1.sw_1.XM6.G.t2 DAC4_0.DAC3_0.DAC2_1.sw_1.vin2 avss.t139 sky130_fd_pr__nfet_01v8 ad=0.145 pd=1.58 as=0.145 ps=1.58 w=0.5 l=0.15
X58 DAC4_0.sw_0.XM6.G.t0 b3 avss.t182 avss.t181 sky130_fd_pr__nfet_01v8 ad=0.145 pd=1.58 as=0.145 ps=1.58 w=0.5 l=0.15
R13 DAC4_0.DAC3_1.DAC2_0.sw_0.vin1 DAC4_0.DAC3_1.DAC2_1.vrefh sky130_fd_pr__res_generic_l1 w=1 l=3.75
X59 DAC4_1.DAC3_1.DAC2_1.vrefh DAC4_1.DAC3_1.DAC2_0.sw_0.XM6.G DAC4_1.DAC3_1.DAC2_0.sw_2.vin2 avss.t13 sky130_fd_pr__nfet_01v8 ad=0.145 pd=1.58 as=0.145 ps=1.58 w=0.5 l=0.15
X60 avdd.t174 DAC4_1.DAC3_0.DAC2_0.sw_2.XM6.G DAC4_1.DAC3_0.DAC2_0.sw_2.XM8.G avdd.t173 sky130_fd_pr__pfet_01v8 ad=0.145 pd=1.58 as=0.145 ps=1.58 w=0.5 l=0.15
R14 DAC4_1.DAC3_0.DAC2_0.sw_1.vin2 DAC4_1.DAC3_0.DAC2_0.sw_1.vin1 sky130_fd_pr__res_generic_l1 w=1 l=3.75
R15 DAC4_1.DAC3_1.DAC2_1.vrefh DAC4_1.DAC3_1.DAC2_0.sw_0.vin1 sky130_fd_pr__res_generic_l1 w=1 l=3.75
X61 DAC4_0.DAC3_1.sw_0.vin2 DAC4_0.DAC3_1.DAC2_1.sw_2.XM6.G.t4 DAC4_0.DAC3_1.DAC2_1.sw_2.vin1 avdd.t177 sky130_fd_pr__pfet_01v8 ad=0.145 pd=1.58 as=0.145 ps=1.58 w=0.5 l=0.15
X62 DAC4_0.DAC3_1.sw_0.vin2 DAC4_0.DAC3_1.sw_0.XM8.G DAC4_0.sw_0.vin2 avdd.t6 sky130_fd_pr__pfet_01v8 ad=0.145 pd=1.58 as=0.145 ps=1.58 w=0.5 l=0.15
X63 avss.t73 DAC4_1.DAC3_1.DAC2_1.sw_1.XM6.G DAC4_1.DAC3_1.DAC2_1.sw_1.XM8.G avss.t72 sky130_fd_pr__nfet_01v8 ad=0.145 pd=1.58 as=0.145 ps=1.58 w=0.5 l=0.15
X64 avdd.t76 b0 DAC4_1.DAC3_1.DAC2_0.sw_0.XM6.G avdd.t75 sky130_fd_pr__pfet_01v8 ad=0.145 pd=1.58 as=0.145 ps=1.58 w=0.5 l=0.15
X65 DAC4_0.DAC3_0.DAC2_1.sw_2.vin1 DAC4_0.DAC3_0.DAC2_1.sw_2.XM8.G DAC4_0.DAC3_0.sw_0.vin2 avss.t166 sky130_fd_pr__nfet_01v8 ad=0.145 pd=1.58 as=0.145 ps=1.58 w=0.5 l=0.15
X66 DAC4_1.DAC3_0.DAC2_1.sw_1.vin1 DAC4_1.DAC3_0.DAC2_1.sw_1.XM6.G DAC4_1.DAC3_0.DAC2_1.sw_2.vin1 avdd.t33 sky130_fd_pr__pfet_01v8 ad=0.145 pd=1.58 as=0.145 ps=1.58 w=0.5 l=0.15
X67 DAC4_0.DAC3_1.DAC2_1.sw_0.XM8.G DAC4_0.DAC3_1.DAC2_1.sw_0.XM6.G.t3 avss.t169 avss.t168 sky130_fd_pr__nfet_01v8 ad=0.145 pd=1.58 as=0.145 ps=1.58 w=0.5 l=0.15
X68 DAC4_0.DAC3_0.sw_0.XM8.G DAC4_0.DAC3_0.sw_0.XM6.G.t3 avss.t28 avss.t27 sky130_fd_pr__nfet_01v8 ad=0.145 pd=1.58 as=0.145 ps=1.58 w=0.5 l=0.15
X69 DAC4_0.DAC3_1.DAC2_0.sw_1.XM6.G.t1 b0 avdd.t94 avdd.t93 sky130_fd_pr__pfet_01v8 ad=0.145 pd=1.58 as=0.145 ps=1.58 w=0.5 l=0.15
X70 DAC4_1.sw_0.vin1 DAC4_1.DAC3_0.sw_0.XM8.G DAC4_1.DAC3_0.sw_0.vin2 avdd.t63 sky130_fd_pr__pfet_01v8 ad=0.145 pd=1.58 as=0.145 ps=1.58 w=0.5 l=0.15
X71 DAC4_1.sw_0.vin1 DAC4_1.DAC3_0.sw_0.XM8.G DAC4_1.DAC3_0.sw_0.vin1 avss.t70 sky130_fd_pr__nfet_01v8 ad=0.145 pd=1.58 as=0.145 ps=1.58 w=0.5 l=0.15
X72 DAC4_0.DAC3_0.DAC2_0.sw_0.vin1 DAC4_0.DAC3_0.DAC2_0.sw_0.XM8.G DAC4_0.DAC3_0.DAC2_0.sw_2.vin2 avss.t32 sky130_fd_pr__nfet_01v8 ad=0.145 pd=1.58 as=0.145 ps=1.58 w=0.5 l=0.15
X73 DAC4_0.DAC3_0.sw_0.vin1 DAC4_0.DAC3_0.sw_0.XM8.G DAC4_0.sw_0.vin1 avss.t135 sky130_fd_pr__nfet_01v8 ad=0.145 pd=1.58 as=0.145 ps=1.58 w=0.5 l=0.15
X74 vout sw_0.XM6.G.t5 sw_0.vin1 avdd.t56 sky130_fd_pr__pfet_01v8 ad=0.145 pd=1.58 as=0.145 ps=1.58 w=0.5 l=0.15
X75 DAC4_1.DAC3_0.sw_0.vin2 DAC4_1.DAC3_0.DAC2_1.sw_2.XM8.G DAC4_1.DAC3_0.DAC2_1.sw_2.vin1 avss.t36 sky130_fd_pr__nfet_01v8 ad=0.145 pd=1.58 as=0.145 ps=1.58 w=0.5 l=0.15
X76 avss.t103 b0 DAC4_1.DAC3_0.DAC2_0.sw_0.XM6.G avss.t102 sky130_fd_pr__nfet_01v8 ad=0.145 pd=1.58 as=0.145 ps=1.58 w=0.5 l=0.15
X77 DAC4_1.sw_0.vin2 DAC4_1.DAC3_1.sw_0.XM8.G DAC4_1.DAC3_1.sw_0.vin2 avdd.t25 sky130_fd_pr__pfet_01v8 ad=0.145 pd=1.58 as=0.145 ps=1.58 w=0.5 l=0.15
X78 DAC4_0.DAC3_1.DAC2_1.sw_0.XM6.G.t1 b0 avdd.t104 avdd.t103 sky130_fd_pr__pfet_01v8 ad=0.145 pd=1.58 as=0.145 ps=1.58 w=0.5 l=0.15
X79 DAC4_0.DAC3_0.DAC2_0.sw_2.XM6.G.t1 b1 avdd.t118 avdd.t117 sky130_fd_pr__pfet_01v8 ad=0.145 pd=1.58 as=0.145 ps=1.58 w=0.5 l=0.15
R16 DAC4_0.DAC3_1.DAC2_1.vrefh DAC4_0.DAC3_1.DAC2_1.sw_1.vin1 sky130_fd_pr__res_generic_l1 w=1 l=3.75
X80 DAC4_1.DAC3_1.DAC2_0.sw_2.vin1 DAC4_1.DAC3_1.DAC2_0.sw_1.XM8.G DAC4_1.DAC3_1.DAC2_0.sw_1.vin2 avdd.t166 sky130_fd_pr__pfet_01v8 ad=0.145 pd=1.58 as=0.145 ps=1.58 w=0.5 l=0.15
X81 vout sw_0.XM6.G.t3 sw_0.vin2 avss.t69 sky130_fd_pr__nfet_01v8 ad=0.145 pd=1.58 as=0.145 ps=1.58 w=0.5 l=0.15
X82 DAC4_0.DAC3_1.sw_0.XM6.G.t1 b2 avdd.t144 avdd.t143 sky130_fd_pr__pfet_01v8 ad=0.145 pd=1.58 as=0.145 ps=1.58 w=0.5 l=0.15
X83 DAC4_0.DAC3_0.DAC2_1.sw_2.XM6.G.t0 b1 avss.t125 avss.t124 sky130_fd_pr__nfet_01v8 ad=0.145 pd=1.58 as=0.145 ps=1.58 w=0.5 l=0.15
X84 DAC4_0.DAC3_0.sw_0.vin1 DAC4_0.DAC3_0.DAC2_0.sw_2.XM6.G.t2 DAC4_0.DAC3_0.DAC2_0.sw_2.vin2 avss.t26 sky130_fd_pr__nfet_01v8 ad=0.145 pd=1.58 as=0.145 ps=1.58 w=0.5 l=0.15
X85 avdd.t92 b0 DAC4_1.DAC3_0.DAC2_1.sw_0.XM6.G avdd.t91 sky130_fd_pr__pfet_01v8 ad=0.145 pd=1.58 as=0.145 ps=1.58 w=0.5 l=0.15
R17 DAC4_0.DAC3_1.DAC2_1.sw_1.vin1 DAC4_0.DAC3_1.DAC2_1.sw_1.vin2 sky130_fd_pr__res_generic_l1 w=1 l=3.75
X86 avss.t81 b0 DAC4_1.DAC3_1.DAC2_0.sw_0.XM6.G avss.t80 sky130_fd_pr__nfet_01v8 ad=0.145 pd=1.58 as=0.145 ps=1.58 w=0.5 l=0.15
R18 vrefh DAC4_0.DAC3_0.DAC2_0.sw_1.vin1 sky130_fd_pr__res_generic_l1 w=1 l=3.75
X87 avdd.t18 DAC4_1.DAC3_1.DAC2_0.sw_1.XM6.G DAC4_1.DAC3_1.DAC2_0.sw_1.XM8.G avdd.t17 sky130_fd_pr__pfet_01v8 ad=0.145 pd=1.58 as=0.145 ps=1.58 w=0.5 l=0.15
R19 DAC4_0.DAC3_0.DAC2_1.sw_1.vin1 DAC4_0.DAC3_0.DAC2_1.sw_1.vin2 sky130_fd_pr__res_generic_l1 w=1 l=3.75
X88 DAC4_0.sw_0.vin1 DAC4_0.DAC3_0.sw_0.XM6.G.t4 DAC4_0.DAC3_0.sw_0.vin1 avdd.t178 sky130_fd_pr__pfet_01v8 ad=0.145 pd=1.58 as=0.145 ps=1.58 w=0.5 l=0.15
X89 DAC4_1.DAC3_0.DAC2_1.sw_2.vin2 DAC4_1.DAC3_0.DAC2_1.sw_0.XM8.G DAC4_1.DAC3_0.DAC2_1.sw_0.vin1 avss.t31 sky130_fd_pr__nfet_01v8 ad=0.145 pd=1.58 as=0.145 ps=1.58 w=0.5 l=0.15
X90 DAC4_0.DAC3_1.DAC2_0.sw_2.vin1 DAC4_0.DAC3_1.DAC2_0.sw_1.XM6.G.t4 DAC4_0.DAC3_1.DAC2_0.sw_1.vin1 avdd.t36 sky130_fd_pr__pfet_01v8 ad=0.145 pd=1.58 as=0.145 ps=1.58 w=0.5 l=0.15
X91 DAC4_0.DAC3_0.DAC2_1.sw_2.vin1 DAC4_0.DAC3_0.DAC2_1.sw_1.XM6.G.t4 DAC4_0.DAC3_0.DAC2_1.sw_1.vin1 avdd.t129 sky130_fd_pr__pfet_01v8 ad=0.145 pd=1.58 as=0.145 ps=1.58 w=0.5 l=0.15
X92 sw_0.vin2 sw_0.XM8.G vout avdd.t56 sky130_fd_pr__pfet_01v8 ad=0.145 pd=1.58 as=0.145 ps=1.58 w=0.5 l=0.15
X93 DAC4_0.DAC3_1.DAC2_1.sw_1.XM6.G.t0 b0 avss.t79 avss.t78 sky130_fd_pr__nfet_01v8 ad=0.145 pd=1.58 as=0.145 ps=1.58 w=0.5 l=0.15
X94 DAC4_0.DAC3_0.DAC2_1.sw_0.XM8.G DAC4_0.DAC3_0.DAC2_1.sw_0.XM6.G.t5 avdd.t54 avdd.t53 sky130_fd_pr__pfet_01v8 ad=0.145 pd=1.58 as=0.145 ps=1.58 w=0.5 l=0.15
R20 DAC4_0.DAC3_0.DAC2_0.sw_1.vin1 DAC4_0.DAC3_0.DAC2_0.sw_1.vin2 sky130_fd_pr__res_generic_l1 w=1 l=3.75
X95 DAC4_0.sw_0.XM8.G DAC4_0.sw_0.XM6.G.t3 avss.t47 avss.t46 sky130_fd_pr__nfet_01v8 ad=0.145 pd=1.58 as=0.145 ps=1.58 w=0.5 l=0.15
X96 DAC4_0.DAC3_1.sw_0.vin1 DAC4_0.DAC3_1.DAC2_0.sw_2.XM6.G.t2 DAC4_0.DAC3_1.DAC2_0.sw_2.vin2 avss.t132 sky130_fd_pr__nfet_01v8 ad=0.145 pd=1.58 as=0.145 ps=1.58 w=0.5 l=0.15
R21 DAC4_0.DAC3_0.DAC2_1.sw_1.vin2 DAC4_0.DAC3_0.DAC2_1.sw_0.vin1 sky130_fd_pr__res_generic_l1 w=1 l=3.75
X97 DAC4_1.DAC3_0.DAC2_0.sw_2.vin1 DAC4_1.DAC3_0.DAC2_0.sw_1.XM8.G DAC4_1.DAC3_0.DAC2_0.sw_1.vin1 avss.t54 sky130_fd_pr__nfet_01v8 ad=0.145 pd=1.58 as=0.145 ps=1.58 w=0.5 l=0.15
X98 avdd.t24 DAC4_1.DAC3_0.sw_0.XM6.G DAC4_1.DAC3_0.sw_0.XM8.G avdd.t23 sky130_fd_pr__pfet_01v8 ad=0.145 pd=1.58 as=0.145 ps=1.58 w=0.5 l=0.15
X99 avss.t25 DAC4_1.DAC3_0.sw_0.XM6.G DAC4_1.DAC3_0.sw_0.XM8.G avss.t24 sky130_fd_pr__nfet_01v8 ad=0.145 pd=1.58 as=0.145 ps=1.58 w=0.5 l=0.15
X100 avss.t99 b0 DAC4_1.DAC3_0.DAC2_1.sw_1.XM6.G avss.t98 sky130_fd_pr__nfet_01v8 ad=0.145 pd=1.58 as=0.145 ps=1.58 w=0.5 l=0.15
X101 DAC4_0.DAC3_1.DAC2_1.sw_2.vin2 DAC4_0.DAC3_1.DAC2_1.sw_0.XM6.G.t4 DAC4_0.DAC3_1.DAC2_1.sw_0.vin1 avdd.t58 sky130_fd_pr__pfet_01v8 ad=0.145 pd=1.58 as=0.145 ps=1.58 w=0.5 l=0.15
X102 DAC4_1.DAC3_1.sw_0.vin2 DAC4_1.DAC3_1.DAC2_1.sw_2.XM8.G DAC4_1.DAC3_1.DAC2_1.sw_2.vin1 avss.t34 sky130_fd_pr__nfet_01v8 ad=0.145 pd=1.58 as=0.145 ps=1.58 w=0.5 l=0.15
X103 avdd.t69 DAC4_1.DAC3_1.sw_0.XM6.G DAC4_1.DAC3_1.sw_0.XM8.G avdd.t68 sky130_fd_pr__pfet_01v8 ad=0.145 pd=1.58 as=0.145 ps=1.58 w=0.5 l=0.15
R22 DAC4_0.DAC3_0.DAC2_0.sw_1.vin2 DAC4_0.DAC3_0.DAC2_0.sw_0.vin1 sky130_fd_pr__res_generic_l1 w=1 l=3.75
X104 avdd.t61 DAC4_1.DAC3_1.DAC2_1.sw_0.XM6.G DAC4_1.DAC3_1.DAC2_1.sw_0.XM8.G avdd.t60 sky130_fd_pr__pfet_01v8 ad=0.145 pd=1.58 as=0.145 ps=1.58 w=0.5 l=0.15
X105 DAC4_1.sw_0.vin2 DAC4_1.sw_0.XM6.G sw_0.vin2 avss.t171 sky130_fd_pr__nfet_01v8 ad=0.145 pd=1.58 as=0.145 ps=1.58 w=0.5 l=0.15
R23 DAC4_0.DAC3_0.DAC2_1.sw_0.vin1 DAC4_0.DAC3_1.vrefh sky130_fd_pr__res_generic_l1 w=1 l=3.75
X106 avss.t45 DAC4_1.DAC3_0.DAC2_0.sw_1.XM6.G DAC4_1.DAC3_0.DAC2_0.sw_1.XM8.G avss.t44 sky130_fd_pr__nfet_01v8 ad=0.145 pd=1.58 as=0.145 ps=1.58 w=0.5 l=0.15
X107 avss.t5 DAC4_1.DAC3_1.DAC2_1.sw_2.XM6.G DAC4_1.DAC3_1.DAC2_1.sw_2.XM8.G avss.t4 sky130_fd_pr__nfet_01v8 ad=0.145 pd=1.58 as=0.145 ps=1.58 w=0.5 l=0.15
X108 sw_0.vin1 sw_0.XM8.G vout avss.t69 sky130_fd_pr__nfet_01v8 ad=0.145 pd=1.58 as=0.145 ps=1.58 w=0.5 l=0.15
X109 DAC4_1.DAC3_1.sw_0.vin1 DAC4_1.DAC3_1.DAC2_0.sw_2.XM8.G DAC4_1.DAC3_1.DAC2_0.sw_2.vin2 avdd.t62 sky130_fd_pr__pfet_01v8 ad=0.145 pd=1.58 as=0.145 ps=1.58 w=0.5 l=0.15
X110 sw_0.vin1 DAC4_0.sw_0.XM6.G.t2 DAC4_0.sw_0.vin2 avss.t110 sky130_fd_pr__nfet_01v8 ad=0.145 pd=1.58 as=0.145 ps=1.58 w=0.5 l=0.15
X111 DAC4_1.sw_0.vin1 DAC4_1.sw_0.XM6.G sw_0.vin2 avdd.t167 sky130_fd_pr__pfet_01v8 ad=0.145 pd=1.58 as=0.145 ps=1.58 w=0.5 l=0.15
X112 DAC4_0.DAC3_0.DAC2_1.sw_1.XM6.G.t1 b0 avdd.t88 avdd.t87 sky130_fd_pr__pfet_01v8 ad=0.145 pd=1.58 as=0.145 ps=1.58 w=0.5 l=0.15
X113 avss.t127 b1 DAC4_1.DAC3_0.DAC2_1.sw_2.XM6.G avss.t126 sky130_fd_pr__nfet_01v8 ad=0.145 pd=1.58 as=0.145 ps=1.58 w=0.5 l=0.15
X114 DAC4_0.DAC3_1.DAC2_0.sw_0.XM6.G.t0 b0 avss.t107 avss.t106 sky130_fd_pr__nfet_01v8 ad=0.145 pd=1.58 as=0.145 ps=1.58 w=0.5 l=0.15
X115 DAC4_0.DAC3_1.DAC2_1.sw_2.XM8.G DAC4_0.DAC3_1.DAC2_1.sw_2.XM6.G.t3 avss.t138 avss.t137 sky130_fd_pr__nfet_01v8 ad=0.145 pd=1.58 as=0.145 ps=1.58 w=0.5 l=0.15
X116 DAC4_1.DAC3_0.DAC2_0.sw_0.vin1 DAC4_1.DAC3_0.DAC2_0.sw_0.XM6.G DAC4_1.DAC3_0.DAC2_0.sw_2.vin2 avdd.t43 sky130_fd_pr__pfet_01v8 ad=0.145 pd=1.58 as=0.145 ps=1.58 w=0.5 l=0.15
X117 DAC4_0.DAC3_0.DAC2_0.sw_1.XM8.G DAC4_0.DAC3_0.DAC2_0.sw_1.XM6.G.t5 avdd.t160 avdd.t159 sky130_fd_pr__pfet_01v8 ad=0.145 pd=1.58 as=0.145 ps=1.58 w=0.5 l=0.15
X118 DAC4_1.DAC3_1.DAC2_0.sw_2.vin2 DAC4_1.DAC3_1.DAC2_0.sw_0.XM8.G DAC4_1.DAC3_1.DAC2_0.sw_0.vin1 avss.t12 sky130_fd_pr__nfet_01v8 ad=0.145 pd=1.58 as=0.145 ps=1.58 w=0.5 l=0.15
R24 DAC4_0.DAC3_0.DAC2_0.sw_0.vin1 DAC4_0.DAC3_0.DAC2_1.vrefh sky130_fd_pr__res_generic_l1 w=1 l=3.75
X119 DAC4_0.DAC3_1.sw_0.XM8.G DAC4_0.DAC3_1.sw_0.XM6.G.t3 avss.t134 avss.t133 sky130_fd_pr__nfet_01v8 ad=0.145 pd=1.58 as=0.145 ps=1.58 w=0.5 l=0.15
X120 DAC4_0.DAC3_1.DAC2_0.sw_0.XM8.G DAC4_0.DAC3_1.DAC2_0.sw_0.XM6.G.t5 avdd.t48 avdd.t47 sky130_fd_pr__pfet_01v8 ad=0.145 pd=1.58 as=0.145 ps=1.58 w=0.5 l=0.15
X121 DAC4_0.DAC3_0.DAC2_1.sw_2.XM8.G DAC4_0.DAC3_0.DAC2_1.sw_2.XM6.G.t5 avdd.t176 avdd.t175 sky130_fd_pr__pfet_01v8 ad=0.145 pd=1.58 as=0.145 ps=1.58 w=0.5 l=0.15
X122 DAC4_1.DAC3_1.sw_0.vin1 DAC4_1.DAC3_1.DAC2_0.sw_2.XM8.G DAC4_1.DAC3_1.DAC2_0.sw_2.vin1 avss.t68 sky130_fd_pr__nfet_01v8 ad=0.145 pd=1.58 as=0.145 ps=1.58 w=0.5 l=0.15
X123 DAC4_0.DAC3_1.DAC2_1.sw_2.vin1 DAC4_0.DAC3_1.DAC2_1.sw_1.XM6.G.t2 DAC4_0.DAC3_1.DAC2_1.sw_1.vin2 avss.t64 sky130_fd_pr__nfet_01v8 ad=0.145 pd=1.58 as=0.145 ps=1.58 w=0.5 l=0.15
X124 DAC4_0.DAC3_0.sw_0.XM6.G.t0 b2 avss.t159 avss.t158 sky130_fd_pr__nfet_01v8 ad=0.145 pd=1.58 as=0.145 ps=1.58 w=0.5 l=0.15
X125 avss.t157 b2 DAC4_1.DAC3_1.sw_0.XM6.G avss.t156 sky130_fd_pr__nfet_01v8 ad=0.145 pd=1.58 as=0.145 ps=1.58 w=0.5 l=0.15
X126 DAC4_0.DAC3_0.DAC2_0.sw_0.XM8.G DAC4_0.DAC3_0.DAC2_0.sw_0.XM6.G.t5 avdd.t132 avdd.t131 sky130_fd_pr__pfet_01v8 ad=0.145 pd=1.58 as=0.145 ps=1.58 w=0.5 l=0.15
X127 DAC4_1.DAC3_1.DAC2_1.sw_1.vin1 DAC4_1.DAC3_1.DAC2_1.sw_1.XM6.G DAC4_1.DAC3_1.DAC2_1.sw_2.vin1 avdd.t64 sky130_fd_pr__pfet_01v8 ad=0.145 pd=1.58 as=0.145 ps=1.58 w=0.5 l=0.15
X128 avdd.t100 b0 DAC4_1.DAC3_0.DAC2_0.sw_1.XM6.G avdd.t99 sky130_fd_pr__pfet_01v8 ad=0.145 pd=1.58 as=0.145 ps=1.58 w=0.5 l=0.15
X129 DAC4_1.DAC3_0.sw_0.vin1 DAC4_1.DAC3_0.DAC2_0.sw_2.XM8.G DAC4_1.DAC3_0.DAC2_0.sw_2.vin1 avss.t42 sky130_fd_pr__nfet_01v8 ad=0.145 pd=1.58 as=0.145 ps=1.58 w=0.5 l=0.15
X130 DAC4_0.DAC3_1.vrefh.t0 DAC4_0.DAC3_0.DAC2_1.sw_0.XM8.G DAC4_0.DAC3_0.DAC2_1.sw_2.vin2 avdd.t26 sky130_fd_pr__pfet_01v8 ad=0.145 pd=1.58 as=0.145 ps=1.58 w=0.5 l=0.15
X131 DAC4_0.DAC3_0.DAC2_0.sw_2.vin1 DAC4_0.DAC3_0.DAC2_0.sw_1.XM6.G.t2 DAC4_0.DAC3_0.DAC2_0.sw_1.vin2 avss.t57 sky130_fd_pr__nfet_01v8 ad=0.145 pd=1.58 as=0.145 ps=1.58 w=0.5 l=0.15
X132 DAC4_1.DAC3_1.DAC2_0.sw_2.vin2 DAC4_1.DAC3_1.DAC2_0.sw_0.XM8.G DAC4_1.DAC3_1.DAC2_1.vrefh avdd.t11 sky130_fd_pr__pfet_01v8 ad=0.145 pd=1.58 as=0.145 ps=1.58 w=0.5 l=0.15
X133 DAC4_0.sw_0.vin2 DAC4_0.sw_0.XM8.G sw_0.vin1 avdd.t15 sky130_fd_pr__pfet_01v8 ad=0.145 pd=1.58 as=0.145 ps=1.58 w=0.5 l=0.15
X134 DAC4_0.DAC3_0.sw_0.vin2 DAC4_0.DAC3_0.DAC2_1.sw_2.XM6.G.t2 DAC4_0.DAC3_0.DAC2_1.sw_2.vin2 avss.t48 sky130_fd_pr__nfet_01v8 ad=0.145 pd=1.58 as=0.145 ps=1.58 w=0.5 l=0.15
X135 DAC4_1.DAC3_0.DAC2_0.sw_2.vin2 DAC4_1.DAC3_0.DAC2_0.sw_0.XM8.G DAC4_1.DAC3_0.DAC2_0.sw_0.vin1 avss.t8 sky130_fd_pr__nfet_01v8 ad=0.145 pd=1.58 as=0.145 ps=1.58 w=0.5 l=0.15
X136 DAC4_1.DAC3_1.DAC2_1.sw_1.vin2 DAC4_1.DAC3_1.DAC2_1.sw_1.XM6.G DAC4_1.DAC3_1.DAC2_1.sw_2.vin1 avss.t71 sky130_fd_pr__nfet_01v8 ad=0.145 pd=1.58 as=0.145 ps=1.58 w=0.5 l=0.15
X137 sw_0.XM6.G.t1 b4 avdd.t140 avdd.t56 sky130_fd_pr__pfet_01v8 ad=0.145 pd=1.58 as=0.145 ps=1.58 w=0.5 l=0.15
X138 DAC4_0.DAC3_1.DAC2_0.sw_2.vin2 DAC4_0.DAC3_1.DAC2_0.sw_0.XM6.G.t2 DAC4_0.DAC3_1.DAC2_1.vrefh avss.t115 sky130_fd_pr__nfet_01v8 ad=0.145 pd=1.58 as=0.145 ps=1.58 w=0.5 l=0.15
X139 DAC4_0.DAC3_1.DAC2_0.sw_2.XM8.G DAC4_0.DAC3_1.DAC2_0.sw_2.XM6.G.t5 avdd.t106 avdd.t105 sky130_fd_pr__pfet_01v8 ad=0.145 pd=1.58 as=0.145 ps=1.58 w=0.5 l=0.15
X140 DAC4_0.DAC3_1.DAC2_0.sw_1.XM8.G DAC4_0.DAC3_1.DAC2_0.sw_1.XM6.G.t3 avss.t148 avss.t147 sky130_fd_pr__nfet_01v8 ad=0.145 pd=1.58 as=0.145 ps=1.58 w=0.5 l=0.15
X141 DAC4_1.DAC3_0.sw_0.vin2 DAC4_1.DAC3_0.DAC2_1.sw_2.XM8.G DAC4_1.DAC3_0.DAC2_1.sw_2.vin2 avdd.t32 sky130_fd_pr__pfet_01v8 ad=0.145 pd=1.58 as=0.145 ps=1.58 w=0.5 l=0.15
X142 DAC4_0.DAC3_1.DAC2_1.sw_2.vin1 DAC4_0.DAC3_1.DAC2_1.sw_2.XM8.G DAC4_0.DAC3_1.sw_0.vin2 avss.t175 sky130_fd_pr__nfet_01v8 ad=0.145 pd=1.58 as=0.145 ps=1.58 w=0.5 l=0.15
X143 avdd.t102 b0 DAC4_1.DAC3_0.DAC2_0.sw_0.XM6.G avdd.t101 sky130_fd_pr__pfet_01v8 ad=0.145 pd=1.58 as=0.145 ps=1.58 w=0.5 l=0.15
X144 DAC4_0.DAC3_0.DAC2_0.sw_1.vin2 DAC4_0.DAC3_0.DAC2_0.sw_1.XM8.G DAC4_0.DAC3_0.DAC2_0.sw_2.vin1 avdd.t55 sky130_fd_pr__pfet_01v8 ad=0.145 pd=1.58 as=0.145 ps=1.58 w=0.5 l=0.15
X145 DAC4_0.DAC3_0.DAC2_0.sw_1.XM6.G.t0 b0 avss.t89 avss.t88 sky130_fd_pr__nfet_01v8 ad=0.145 pd=1.58 as=0.145 ps=1.58 w=0.5 l=0.15
X146 DAC4_0.DAC3_0.DAC2_0.sw_2.vin2 DAC4_0.DAC3_0.DAC2_0.sw_0.XM6.G.t2 DAC4_0.DAC3_0.DAC2_1.vrefh avss.t41 sky130_fd_pr__nfet_01v8 ad=0.145 pd=1.58 as=0.145 ps=1.58 w=0.5 l=0.15
X147 avdd.t120 b1 DAC4_1.DAC3_1.DAC2_0.sw_2.XM6.G avdd.t119 sky130_fd_pr__pfet_01v8 ad=0.145 pd=1.58 as=0.145 ps=1.58 w=0.5 l=0.15
X148 DAC4_0.DAC3_1.DAC2_1.vrefh DAC4_0.DAC3_1.DAC2_0.sw_0.XM8.G DAC4_0.DAC3_1.DAC2_0.sw_2.vin2 avdd.t107 sky130_fd_pr__pfet_01v8 ad=0.145 pd=1.58 as=0.145 ps=1.58 w=0.5 l=0.15
X149 DAC4_0.DAC3_0.DAC2_1.sw_2.vin2 DAC4_0.DAC3_0.DAC2_1.sw_2.XM8.G DAC4_0.DAC3_0.sw_0.vin2 avdd.t162 sky130_fd_pr__pfet_01v8 ad=0.145 pd=1.58 as=0.145 ps=1.58 w=0.5 l=0.15
X150 DAC4_0.DAC3_0.DAC2_1.sw_0.XM6.G.t0 b0 avss.t95 avss.t94 sky130_fd_pr__nfet_01v8 ad=0.145 pd=1.58 as=0.145 ps=1.58 w=0.5 l=0.15
X151 sw_0.XM6.G.t0 b4 avss.t153 avss.t69 sky130_fd_pr__nfet_01v8 ad=0.145 pd=1.58 as=0.145 ps=1.58 w=0.5 l=0.15
X152 DAC4_1.DAC3_0.DAC2_1.sw_2.vin2 DAC4_1.DAC3_0.DAC2_1.sw_0.XM8.G DAC4_1.DAC3_1.vrefh.t2 avdd.t27 sky130_fd_pr__pfet_01v8 ad=0.145 pd=1.58 as=0.145 ps=1.58 w=0.5 l=0.15
X153 avdd.t86 b0 DAC4_1.DAC3_1.DAC2_1.sw_1.XM6.G avdd.t85 sky130_fd_pr__pfet_01v8 ad=0.145 pd=1.58 as=0.145 ps=1.58 w=0.5 l=0.15
R25 DAC4_1.DAC3_1.vrefh DAC4_1.DAC3_0.DAC2_1.sw_0.vin1 sky130_fd_pr__res_generic_l1 w=1 l=3.75
X154 avdd.t42 DAC4_1.DAC3_0.DAC2_0.sw_1.XM6.G DAC4_1.DAC3_0.DAC2_0.sw_1.XM8.G avdd.t41 sky130_fd_pr__pfet_01v8 ad=0.145 pd=1.58 as=0.145 ps=1.58 w=0.5 l=0.15
X155 DAC4_0.DAC3_0.DAC2_1.vrefh DAC4_0.DAC3_0.DAC2_0.sw_0.XM8.G DAC4_0.DAC3_0.DAC2_0.sw_2.vin2 avdd.t28 sky130_fd_pr__pfet_01v8 ad=0.145 pd=1.58 as=0.145 ps=1.58 w=0.5 l=0.15
X156 DAC4_0.DAC3_0.sw_0.vin1 DAC4_0.DAC3_0.DAC2_0.sw_2.XM6.G.t4 DAC4_0.DAC3_0.DAC2_0.sw_2.vin1 avdd.t156 sky130_fd_pr__pfet_01v8 ad=0.145 pd=1.58 as=0.145 ps=1.58 w=0.5 l=0.15
X157 DAC4_0.DAC3_0.DAC2_0.sw_2.XM8.G DAC4_0.DAC3_0.DAC2_0.sw_2.XM6.G.t3 avss.t11 avss.t10 sky130_fd_pr__nfet_01v8 ad=0.145 pd=1.58 as=0.145 ps=1.58 w=0.5 l=0.15
X158 DAC4_0.DAC3_0.DAC2_0.sw_0.XM6.G.t0 b0 avss.t91 avss.t90 sky130_fd_pr__nfet_01v8 ad=0.145 pd=1.58 as=0.145 ps=1.58 w=0.5 l=0.15
X159 DAC4_1.DAC3_1.DAC2_1.sw_2.vin1 DAC4_1.DAC3_1.DAC2_1.sw_1.XM8.G DAC4_1.DAC3_1.DAC2_1.sw_1.vin2 avdd.t161 sky130_fd_pr__pfet_01v8 ad=0.145 pd=1.58 as=0.145 ps=1.58 w=0.5 l=0.15
X160 avss.t123 b1 DAC4_1.DAC3_1.DAC2_0.sw_2.XM6.G avss.t122 sky130_fd_pr__nfet_01v8 ad=0.145 pd=1.58 as=0.145 ps=1.58 w=0.5 l=0.15
X161 avss.t22 DAC4_1.DAC3_0.DAC2_1.sw_0.XM6.G DAC4_1.DAC3_0.DAC2_1.sw_0.XM8.G avss.t21 sky130_fd_pr__nfet_01v8 ad=0.145 pd=1.58 as=0.145 ps=1.58 w=0.5 l=0.15
X162 avdd.t96 b0 DAC4_1.DAC3_0.DAC2_1.sw_1.XM6.G avdd.t95 sky130_fd_pr__pfet_01v8 ad=0.145 pd=1.58 as=0.145 ps=1.58 w=0.5 l=0.15
X163 avss.t15 DAC4_1.DAC3_1.DAC2_0.sw_0.XM6.G DAC4_1.DAC3_1.DAC2_0.sw_0.XM8.G avss.t14 sky130_fd_pr__nfet_01v8 ad=0.145 pd=1.58 as=0.145 ps=1.58 w=0.5 l=0.15
X164 DAC4_0.DAC3_1.DAC2_1.sw_2.XM6.G.t0 b1 avss.t121 avss.t120 sky130_fd_pr__nfet_01v8 ad=0.145 pd=1.58 as=0.145 ps=1.58 w=0.5 l=0.15
X165 DAC4_0.DAC3_1.DAC2_1.sw_1.XM8.G DAC4_0.DAC3_1.DAC2_1.sw_1.XM6.G.t5 avdd.t152 avdd.t151 sky130_fd_pr__pfet_01v8 ad=0.145 pd=1.58 as=0.145 ps=1.58 w=0.5 l=0.15
X166 DAC4_1.DAC3_1.DAC2_0.sw_1.vin2 DAC4_1.DAC3_1.DAC2_0.sw_1.XM6.G DAC4_1.DAC3_1.DAC2_0.sw_2.vin1 avss.t17 sky130_fd_pr__nfet_01v8 ad=0.145 pd=1.58 as=0.145 ps=1.58 w=0.5 l=0.15
R26 DAC4_1.DAC3_0.DAC2_1.sw_0.vin1 DAC4_1.DAC3_0.DAC2_1.sw_1.vin2 sky130_fd_pr__res_generic_l1 w=1 l=3.75
X167 DAC4_1.DAC3_0.DAC2_1.sw_2.vin1 DAC4_1.DAC3_0.DAC2_1.sw_1.XM8.G DAC4_1.DAC3_0.DAC2_1.sw_1.vin1 avss.t174 sky130_fd_pr__nfet_01v8 ad=0.145 pd=1.58 as=0.145 ps=1.58 w=0.5 l=0.15
R27 DAC4_0.DAC3_1.DAC2_1.sw_0.vin1 DAC4_1.vrefh sky130_fd_pr__res_generic_l1 w=1 l=3.75
X168 avss.t87 b0 DAC4_1.DAC3_1.DAC2_1.sw_1.XM6.G avss.t86 sky130_fd_pr__nfet_01v8 ad=0.145 pd=1.58 as=0.145 ps=1.58 w=0.5 l=0.15
X169 avss.t131 b1 DAC4_1.DAC3_0.DAC2_0.sw_2.XM6.G avss.t130 sky130_fd_pr__nfet_01v8 ad=0.145 pd=1.58 as=0.145 ps=1.58 w=0.5 l=0.15
X170 vrefl DAC4_1.DAC3_1.DAC2_1.sw_0.XM6.G DAC4_1.DAC3_1.DAC2_1.sw_2.vin2 avss.t65 sky130_fd_pr__nfet_01v8 ad=0.145 pd=1.58 as=0.145 ps=1.58 w=0.5 l=0.15
X171 DAC4_0.DAC3_0.DAC2_1.sw_1.XM8.G DAC4_0.DAC3_0.DAC2_1.sw_1.XM6.G.t5 avdd.t71 avdd.t70 sky130_fd_pr__pfet_01v8 ad=0.145 pd=1.58 as=0.145 ps=1.58 w=0.5 l=0.15
X172 DAC4_0.DAC3_0.DAC2_1.sw_2.XM6.G.t1 b1 avdd.t114 avdd.t113 sky130_fd_pr__pfet_01v8 ad=0.145 pd=1.58 as=0.145 ps=1.58 w=0.5 l=0.15
X173 DAC4_1.DAC3_1.DAC2_1.sw_2.vin1 DAC4_1.DAC3_1.DAC2_1.sw_1.XM8.G DAC4_1.DAC3_1.DAC2_1.sw_1.vin1 avss.t165 sky130_fd_pr__nfet_01v8 ad=0.145 pd=1.58 as=0.145 ps=1.58 w=0.5 l=0.15
X174 DAC4_0.sw_0.vin1 DAC4_0.DAC3_0.sw_0.XM6.G.t2 DAC4_0.DAC3_0.sw_0.vin2 avss.t136 sky130_fd_pr__nfet_01v8 ad=0.145 pd=1.58 as=0.145 ps=1.58 w=0.5 l=0.15
X175 DAC4_0.DAC3_1.DAC2_0.sw_2.vin2 DAC4_0.DAC3_1.DAC2_0.sw_2.XM8.G DAC4_0.DAC3_1.sw_0.vin1 avdd.t31 sky130_fd_pr__pfet_01v8 ad=0.145 pd=1.58 as=0.145 ps=1.58 w=0.5 l=0.15
R28 DAC4_1.DAC3_0.DAC2_1.sw_1.vin2 DAC4_1.DAC3_0.DAC2_1.sw_1.vin1 sky130_fd_pr__res_generic_l1 w=1 l=3.75
X176 DAC4_1.DAC3_0.sw_0.vin1 DAC4_1.DAC3_0.sw_0.XM6.G DAC4_1.sw_0.vin1 avdd.t22 sky130_fd_pr__pfet_01v8 ad=0.145 pd=1.58 as=0.145 ps=1.58 w=0.5 l=0.15
X177 DAC4_1.DAC3_0.sw_0.vin2 DAC4_1.DAC3_0.sw_0.XM6.G DAC4_1.sw_0.vin1 avss.t23 sky130_fd_pr__nfet_01v8 ad=0.145 pd=1.58 as=0.145 ps=1.58 w=0.5 l=0.15
X178 DAC4_0.DAC3_1.DAC2_0.sw_1.vin1 DAC4_0.DAC3_1.DAC2_0.sw_1.XM8.G DAC4_0.DAC3_1.DAC2_0.sw_2.vin1 avss.t53 sky130_fd_pr__nfet_01v8 ad=0.145 pd=1.58 as=0.145 ps=1.58 w=0.5 l=0.15
X179 avss.t39 DAC4_1.DAC3_0.DAC2_1.sw_1.XM6.G DAC4_1.DAC3_0.DAC2_1.sw_1.XM8.G avss.t38 sky130_fd_pr__nfet_01v8 ad=0.145 pd=1.58 as=0.145 ps=1.58 w=0.5 l=0.15
X180 DAC4_0.DAC3_1.DAC2_1.sw_0.XM8.G DAC4_0.DAC3_1.DAC2_1.sw_0.XM6.G.t5 avdd.t158 avdd.t157 sky130_fd_pr__pfet_01v8 ad=0.145 pd=1.58 as=0.145 ps=1.58 w=0.5 l=0.15
X181 DAC4_1.DAC3_1.sw_0.vin2 DAC4_1.DAC3_1.DAC2_1.sw_2.XM8.G DAC4_1.DAC3_1.DAC2_1.sw_2.vin2 avdd.t30 sky130_fd_pr__pfet_01v8 ad=0.145 pd=1.58 as=0.145 ps=1.58 w=0.5 l=0.15
X182 DAC4_0.DAC3_0.DAC2_1.sw_2.vin2 DAC4_0.DAC3_0.DAC2_1.sw_0.XM6.G.t2 DAC4_0.DAC3_1.vrefh.t1 avss.t40 sky130_fd_pr__nfet_01v8 ad=0.145 pd=1.58 as=0.145 ps=1.58 w=0.5 l=0.15
X183 sw_0.XM8.G sw_0.XM6.G.t4 avdd.t57 avdd.t56 sky130_fd_pr__pfet_01v8 ad=0.145 pd=1.58 as=0.145 ps=1.58 w=0.5 l=0.15
X184 DAC4_1.DAC3_0.DAC2_1.sw_2.vin2 DAC4_1.DAC3_0.DAC2_1.sw_2.XM6.G DAC4_1.DAC3_0.sw_0.vin2 avss.t162 sky130_fd_pr__nfet_01v8 ad=0.145 pd=1.58 as=0.145 ps=1.58 w=0.5 l=0.15
R29 DAC4_1.DAC3_0.DAC2_0.sw_1.vin1 DAC4_1.vrefh sky130_fd_pr__res_generic_l1 w=1 l=3.75
X185 avdd.t4 DAC4_1.DAC3_1.DAC2_1.sw_2.XM6.G DAC4_1.DAC3_1.DAC2_1.sw_2.XM8.G avdd.t3 sky130_fd_pr__pfet_01v8 ad=0.145 pd=1.58 as=0.145 ps=1.58 w=0.5 l=0.15
X186 DAC4_1.DAC3_1.sw_0.vin2 DAC4_1.DAC3_1.sw_0.XM6.G DAC4_1.sw_0.vin2 avss.t74 sky130_fd_pr__nfet_01v8 ad=0.145 pd=1.58 as=0.145 ps=1.58 w=0.5 l=0.15
X187 sw_0.vin2 DAC4_1.sw_0.XM8.G DAC4_1.sw_0.vin1 avss.t140 sky130_fd_pr__nfet_01v8 ad=0.145 pd=1.58 as=0.145 ps=1.58 w=0.5 l=0.15
X188 DAC4_1.DAC3_0.DAC2_0.sw_1.vin2 DAC4_1.DAC3_0.DAC2_0.sw_1.XM6.G DAC4_1.DAC3_0.DAC2_0.sw_2.vin1 avss.t43 sky130_fd_pr__nfet_01v8 ad=0.145 pd=1.58 as=0.145 ps=1.58 w=0.5 l=0.15
X189 avdd.t146 b2 DAC4_1.DAC3_1.sw_0.XM6.G avdd.t145 sky130_fd_pr__pfet_01v8 ad=0.145 pd=1.58 as=0.145 ps=1.58 w=0.5 l=0.15
X190 sw_0.vin2 DAC4_1.sw_0.XM8.G DAC4_1.sw_0.vin2 avdd.t130 sky130_fd_pr__pfet_01v8 ad=0.145 pd=1.58 as=0.145 ps=1.58 w=0.5 l=0.15
R30 DAC4_1.DAC3_0.DAC2_1.sw_1.vin1 DAC4_1.DAC3_0.DAC2_1.vrefh sky130_fd_pr__res_generic_l1 w=1 l=3.75
X191 avss.t164 DAC4_1.DAC3_0.DAC2_1.sw_2.XM6.G DAC4_1.DAC3_0.DAC2_1.sw_2.XM8.G avss.t163 sky130_fd_pr__nfet_01v8 ad=0.145 pd=1.58 as=0.145 ps=1.58 w=0.5 l=0.15
X192 avdd.t124 b1 DAC4_1.DAC3_0.DAC2_1.sw_2.XM6.G avdd.t123 sky130_fd_pr__pfet_01v8 ad=0.145 pd=1.58 as=0.145 ps=1.58 w=0.5 l=0.15
X193 sw_0.XM8.G sw_0.XM6.G.t2 avss.t152 avss.t69 sky130_fd_pr__nfet_01v8 ad=0.145 pd=1.58 as=0.145 ps=1.58 w=0.5 l=0.15
X194 DAC4_1.DAC3_0.DAC2_0.sw_1.vin1 DAC4_1.DAC3_0.DAC2_0.sw_1.XM6.G DAC4_1.DAC3_0.DAC2_0.sw_2.vin1 avdd.t40 sky130_fd_pr__pfet_01v8 ad=0.145 pd=1.58 as=0.145 ps=1.58 w=0.5 l=0.15
X195 DAC4_1.DAC3_0.sw_0.vin1 DAC4_1.DAC3_0.DAC2_0.sw_2.XM8.G DAC4_1.DAC3_0.DAC2_0.sw_2.vin2 avdd.t39 sky130_fd_pr__pfet_01v8 ad=0.145 pd=1.58 as=0.145 ps=1.58 w=0.5 l=0.15
X196 DAC4_0.DAC3_1.sw_0.XM8.G DAC4_0.DAC3_1.sw_0.XM6.G.t5 avdd.t10 avdd.t9 sky130_fd_pr__pfet_01v8 ad=0.145 pd=1.58 as=0.145 ps=1.58 w=0.5 l=0.15
X197 DAC4_0.DAC3_0.DAC2_0.sw_2.vin1 DAC4_0.DAC3_0.DAC2_0.sw_2.XM8.G DAC4_0.DAC3_0.sw_0.vin1 avss.t2 sky130_fd_pr__nfet_01v8 ad=0.145 pd=1.58 as=0.145 ps=1.58 w=0.5 l=0.15
X198 DAC4_0.DAC3_0.DAC2_1.sw_1.XM8.G DAC4_0.DAC3_0.DAC2_1.sw_1.XM6.G.t3 avss.t7 avss.t6 sky130_fd_pr__nfet_01v8 ad=0.145 pd=1.58 as=0.145 ps=1.58 w=0.5 l=0.15
X199 DAC4_0.DAC3_1.DAC2_0.sw_2.XM6.G.t1 b1 avdd.t116 avdd.t115 sky130_fd_pr__pfet_01v8 ad=0.145 pd=1.58 as=0.145 ps=1.58 w=0.5 l=0.15
X200 DAC4_0.DAC3_1.DAC2_1.sw_1.vin2 DAC4_0.DAC3_1.DAC2_1.sw_1.XM8.G DAC4_0.DAC3_1.DAC2_1.sw_2.vin1 avdd.t29 sky130_fd_pr__pfet_01v8 ad=0.145 pd=1.58 as=0.145 ps=1.58 w=0.5 l=0.15
X201 avss.t93 b0 DAC4_1.DAC3_1.DAC2_0.sw_1.XM6.G avss.t92 sky130_fd_pr__nfet_01v8 ad=0.145 pd=1.58 as=0.145 ps=1.58 w=0.5 l=0.15
X202 DAC4_0.DAC3_1.DAC2_1.sw_2.XM8.G DAC4_0.DAC3_1.DAC2_1.sw_2.XM6.G.t5 avdd.t110 avdd.t109 sky130_fd_pr__pfet_01v8 ad=0.145 pd=1.58 as=0.145 ps=1.58 w=0.5 l=0.15
X203 avdd.t14 DAC4_1.DAC3_1.DAC2_0.sw_0.XM6.G DAC4_1.DAC3_1.DAC2_0.sw_0.XM8.G avdd.t13 sky130_fd_pr__pfet_01v8 ad=0.145 pd=1.58 as=0.145 ps=1.58 w=0.5 l=0.15
X204 avss.t85 b0 DAC4_1.DAC3_1.DAC2_1.sw_0.XM6.G avss.t84 sky130_fd_pr__nfet_01v8 ad=0.145 pd=1.58 as=0.145 ps=1.58 w=0.5 l=0.15
X205 DAC4_0.DAC3_0.DAC2_1.sw_1.vin2 DAC4_0.DAC3_0.DAC2_1.sw_1.XM8.G DAC4_0.DAC3_0.DAC2_1.sw_2.vin1 avdd.t108 sky130_fd_pr__pfet_01v8 ad=0.145 pd=1.58 as=0.145 ps=1.58 w=0.5 l=0.15
X206 DAC4_0.DAC3_0.DAC2_0.sw_1.XM8.G DAC4_0.DAC3_0.DAC2_0.sw_1.XM6.G.t3 avss.t1 avss.t0 sky130_fd_pr__nfet_01v8 ad=0.145 pd=1.58 as=0.145 ps=1.58 w=0.5 l=0.15
X207 DAC4_1.vrefh DAC4_0.DAC3_1.DAC2_1.sw_0.XM8.G DAC4_0.DAC3_1.DAC2_1.sw_2.vin2 avdd.t163 sky130_fd_pr__pfet_01v8 ad=0.145 pd=1.58 as=0.145 ps=1.58 w=0.5 l=0.15
X208 avss.t52 DAC4_1.DAC3_0.DAC2_0.sw_0.XM6.G DAC4_1.DAC3_0.DAC2_0.sw_0.XM8.G avss.t51 sky130_fd_pr__nfet_01v8 ad=0.145 pd=1.58 as=0.145 ps=1.58 w=0.5 l=0.15
X209 DAC4_1.DAC3_0.DAC2_0.sw_2.vin2 DAC4_1.DAC3_0.DAC2_0.sw_0.XM8.G DAC4_1.DAC3_0.DAC2_1.vrefh avdd.t5 sky130_fd_pr__pfet_01v8 ad=0.145 pd=1.58 as=0.145 ps=1.58 w=0.5 l=0.15
X210 DAC4_1.DAC3_1.DAC2_1.sw_2.vin2 DAC4_1.DAC3_1.DAC2_1.sw_2.XM6.G DAC4_1.DAC3_1.sw_0.vin2 avss.t3 sky130_fd_pr__nfet_01v8 ad=0.145 pd=1.58 as=0.145 ps=1.58 w=0.5 l=0.15
X211 DAC4_0.DAC3_1.DAC2_0.sw_0.XM8.G DAC4_0.DAC3_1.DAC2_0.sw_0.XM6.G.t3 avss.t56 avss.t55 sky130_fd_pr__nfet_01v8 ad=0.145 pd=1.58 as=0.145 ps=1.58 w=0.5 l=0.15
X212 DAC4_1.DAC3_0.DAC2_0.sw_2.vin1 DAC4_1.DAC3_0.DAC2_0.sw_1.XM8.G DAC4_1.DAC3_0.DAC2_0.sw_1.vin2 avdd.t50 sky130_fd_pr__pfet_01v8 ad=0.145 pd=1.58 as=0.145 ps=1.58 w=0.5 l=0.15
X213 avss.t117 b1 DAC4_1.DAC3_1.DAC2_1.sw_2.XM6.G avss.t116 sky130_fd_pr__nfet_01v8 ad=0.145 pd=1.58 as=0.145 ps=1.58 w=0.5 l=0.15
X214 DAC4_0.sw_0.XM6.G.t1 b3 avdd.t180 avdd.t179 sky130_fd_pr__pfet_01v8 ad=0.145 pd=1.58 as=0.145 ps=1.58 w=0.5 l=0.15
X215 DAC4_0.sw_0.vin1 DAC4_0.sw_0.XM8.G sw_0.vin1 avss.t16 sky130_fd_pr__nfet_01v8 ad=0.145 pd=1.58 as=0.145 ps=1.58 w=0.5 l=0.15
X216 DAC4_0.DAC3_1.sw_0.vin2 DAC4_0.DAC3_1.DAC2_1.sw_2.XM6.G.t2 DAC4_0.DAC3_1.DAC2_1.sw_2.vin2 avss.t77 sky130_fd_pr__nfet_01v8 ad=0.145 pd=1.58 as=0.145 ps=1.58 w=0.5 l=0.15
R31 DAC4_0.DAC3_0.DAC2_1.vrefh DAC4_0.DAC3_0.DAC2_1.sw_1.vin1 sky130_fd_pr__res_generic_l1 w=1 l=3.75
X217 DAC4_0.sw_0.vin2 DAC4_0.DAC3_1.sw_0.XM6.G.t2 DAC4_0.DAC3_1.sw_0.vin2 avss.t49 sky130_fd_pr__nfet_01v8 ad=0.145 pd=1.58 as=0.145 ps=1.58 w=0.5 l=0.15
X218 avss.t180 b3 DAC4_1.sw_0.XM6.G avss.t179 sky130_fd_pr__nfet_01v8 ad=0.145 pd=1.58 as=0.145 ps=1.58 w=0.5 l=0.15
X219 avdd.t182 b3 DAC4_1.sw_0.XM6.G avdd.t181 sky130_fd_pr__pfet_01v8 ad=0.145 pd=1.58 as=0.145 ps=1.58 w=0.5 l=0.15
X220 DAC4_0.DAC3_1.DAC2_0.sw_1.XM6.G.t0 b0 avss.t105 avss.t104 sky130_fd_pr__nfet_01v8 ad=0.145 pd=1.58 as=0.145 ps=1.58 w=0.5 l=0.15
X221 avdd.t21 DAC4_1.DAC3_0.DAC2_1.sw_0.XM6.G DAC4_1.DAC3_0.DAC2_1.sw_0.XM8.G avdd.t20 sky130_fd_pr__pfet_01v8 ad=0.145 pd=1.58 as=0.145 ps=1.58 w=0.5 l=0.15
X222 DAC4_0.DAC3_0.DAC2_1.sw_1.vin1 DAC4_0.DAC3_0.DAC2_1.sw_1.XM8.G DAC4_0.DAC3_0.DAC2_1.sw_2.vin1 avss.t114 sky130_fd_pr__nfet_01v8 ad=0.145 pd=1.58 as=0.145 ps=1.58 w=0.5 l=0.15
X223 avdd.t135 DAC4_1.DAC3_1.DAC2_0.sw_2.XM6.G DAC4_1.DAC3_1.DAC2_0.sw_2.XM8.G avdd.t134 sky130_fd_pr__pfet_01v8 ad=0.145 pd=1.58 as=0.145 ps=1.58 w=0.5 l=0.15
X224 DAC4_1.DAC3_1.DAC2_1.sw_2.vin2 DAC4_1.DAC3_1.DAC2_1.sw_0.XM8.G DAC4_1.DAC3_1.DAC2_1.sw_0.vin1 avss.t146 sky130_fd_pr__nfet_01v8 ad=0.145 pd=1.58 as=0.145 ps=1.58 w=0.5 l=0.15
X225 DAC4_0.DAC3_0.sw_0.vin2 DAC4_0.DAC3_0.DAC2_1.sw_2.XM6.G.t4 DAC4_0.DAC3_0.DAC2_1.sw_2.vin1 avdd.t51 sky130_fd_pr__pfet_01v8 ad=0.145 pd=1.58 as=0.145 ps=1.58 w=0.5 l=0.15
X226 DAC4_1.DAC3_1.DAC2_0.sw_1.vin1 DAC4_1.DAC3_1.DAC2_0.sw_1.XM6.G DAC4_1.DAC3_1.DAC2_0.sw_2.vin1 avdd.t16 sky130_fd_pr__pfet_01v8 ad=0.145 pd=1.58 as=0.145 ps=1.58 w=0.5 l=0.15
X227 DAC4_1.DAC3_0.DAC2_1.sw_2.vin1 DAC4_1.DAC3_0.DAC2_1.sw_1.XM8.G DAC4_1.DAC3_0.DAC2_1.sw_1.vin2 avdd.t170 sky130_fd_pr__pfet_01v8 ad=0.145 pd=1.58 as=0.145 ps=1.58 w=0.5 l=0.15
X228 DAC4_0.DAC3_0.sw_0.XM8.G DAC4_0.DAC3_0.sw_0.XM6.G.t5 avdd.t150 avdd.t149 sky130_fd_pr__pfet_01v8 ad=0.145 pd=1.58 as=0.145 ps=1.58 w=0.5 l=0.15
X229 avdd.t126 b1 DAC4_1.DAC3_0.DAC2_0.sw_2.XM6.G avdd.t125 sky130_fd_pr__pfet_01v8 ad=0.145 pd=1.58 as=0.145 ps=1.58 w=0.5 l=0.15
X230 DAC4_0.DAC3_1.sw_0.vin1 DAC4_0.DAC3_1.sw_0.XM8.G DAC4_0.sw_0.vin2 avss.t9 sky130_fd_pr__nfet_01v8 ad=0.145 pd=1.58 as=0.145 ps=1.58 w=0.5 l=0.15
X231 DAC4_0.DAC3_1.DAC2_0.sw_1.XM8.G DAC4_0.DAC3_1.DAC2_0.sw_1.XM6.G.t5 avdd.t137 avdd.t136 sky130_fd_pr__pfet_01v8 ad=0.145 pd=1.58 as=0.145 ps=1.58 w=0.5 l=0.15
X232 DAC4_0.DAC3_1.DAC2_1.sw_2.vin2 DAC4_0.DAC3_1.DAC2_1.sw_2.XM8.G DAC4_0.DAC3_1.sw_0.vin2 avdd.t171 sky130_fd_pr__pfet_01v8 ad=0.145 pd=1.58 as=0.145 ps=1.58 w=0.5 l=0.15
X233 DAC4_0.DAC3_0.sw_0.vin2 DAC4_0.DAC3_0.sw_0.XM8.G DAC4_0.sw_0.vin1 avdd.t128 sky130_fd_pr__pfet_01v8 ad=0.145 pd=1.58 as=0.145 ps=1.58 w=0.5 l=0.15
X234 DAC4_0.DAC3_0.DAC2_0.sw_2.vin2 DAC4_0.DAC3_0.DAC2_0.sw_0.XM6.G.t4 DAC4_0.DAC3_0.DAC2_0.sw_0.vin1 avdd.t52 sky130_fd_pr__pfet_01v8 ad=0.145 pd=1.58 as=0.145 ps=1.58 w=0.5 l=0.15
X235 DAC4_1.DAC3_0.DAC2_0.sw_2.vin2 DAC4_1.DAC3_0.DAC2_0.sw_2.XM6.G DAC4_1.DAC3_0.sw_0.vin1 avss.t176 sky130_fd_pr__nfet_01v8 ad=0.145 pd=1.58 as=0.145 ps=1.58 w=0.5 l=0.15
X236 avss.t143 DAC4_1.DAC3_1.DAC2_0.sw_2.XM6.G DAC4_1.DAC3_1.DAC2_0.sw_2.XM8.G avss.t142 sky130_fd_pr__nfet_01v8 ad=0.145 pd=1.58 as=0.145 ps=1.58 w=0.5 l=0.15
X237 DAC4_1.DAC3_1.vrefh.t0 DAC4_1.DAC3_0.DAC2_1.sw_0.XM6.G DAC4_1.DAC3_0.DAC2_1.sw_2.vin2 avss.t20 sky130_fd_pr__nfet_01v8 ad=0.145 pd=1.58 as=0.145 ps=1.58 w=0.5 l=0.15
X238 DAC4_0.DAC3_1.DAC2_0.sw_2.XM8.G DAC4_0.DAC3_1.DAC2_0.sw_2.XM6.G.t3 avss.t113 avss.t112 sky130_fd_pr__nfet_01v8 ad=0.145 pd=1.58 as=0.145 ps=1.58 w=0.5 l=0.15
X239 avdd.t35 DAC4_1.DAC3_0.DAC2_1.sw_1.XM6.G DAC4_1.DAC3_0.DAC2_1.sw_1.XM8.G avdd.t34 sky130_fd_pr__pfet_01v8 ad=0.145 pd=1.58 as=0.145 ps=1.58 w=0.5 l=0.15
X240 DAC4_0.DAC3_0.DAC2_0.sw_1.vin1 DAC4_0.DAC3_0.DAC2_0.sw_1.XM8.G DAC4_0.DAC3_0.DAC2_0.sw_2.vin1 avss.t61 sky130_fd_pr__nfet_01v8 ad=0.145 pd=1.58 as=0.145 ps=1.58 w=0.5 l=0.15
X241 DAC4_0.DAC3_0.DAC2_0.sw_2.XM8.G DAC4_0.DAC3_0.DAC2_0.sw_2.XM6.G.t5 avdd.t38 avdd.t37 sky130_fd_pr__pfet_01v8 ad=0.145 pd=1.58 as=0.145 ps=1.58 w=0.5 l=0.15
X242 DAC4_0.DAC3_0.DAC2_1.sw_0.XM6.G.t1 b0 avdd.t90 avdd.t89 sky130_fd_pr__pfet_01v8 ad=0.145 pd=1.58 as=0.145 ps=1.58 w=0.5 l=0.15
X243 DAC4_1.DAC3_1.sw_0.vin1 DAC4_1.DAC3_1.sw_0.XM6.G DAC4_1.sw_0.vin2 avdd.t67 sky130_fd_pr__pfet_01v8 ad=0.145 pd=1.58 as=0.145 ps=1.58 w=0.5 l=0.15
X244 avss.t178 DAC4_1.DAC3_0.DAC2_0.sw_2.XM6.G DAC4_1.DAC3_0.DAC2_0.sw_2.XM8.G avss.t177 sky130_fd_pr__nfet_01v8 ad=0.145 pd=1.58 as=0.145 ps=1.58 w=0.5 l=0.15
X245 DAC4_1.DAC3_1.DAC2_1.sw_0.vin1 DAC4_1.DAC3_1.DAC2_1.sw_0.XM6.G DAC4_1.DAC3_1.DAC2_1.sw_2.vin2 avdd.t59 sky130_fd_pr__pfet_01v8 ad=0.145 pd=1.58 as=0.145 ps=1.58 w=0.5 l=0.15
X246 DAC4_0.DAC3_0.DAC2_0.sw_2.XM6.G.t0 b1 avss.t119 avss.t118 sky130_fd_pr__nfet_01v8 ad=0.145 pd=1.58 as=0.145 ps=1.58 w=0.5 l=0.15
X247 DAC4_0.DAC3_1.DAC2_1.sw_1.XM6.G.t1 b0 avdd.t74 avdd.t73 sky130_fd_pr__pfet_01v8 ad=0.145 pd=1.58 as=0.145 ps=1.58 w=0.5 l=0.15
R32 avdd.n156 avdd.n154 1260
R33 avdd.n174 avdd.n173 1260
R34 avdd.n181 avdd.n180 1260
R35 avdd.n199 avdd.n124 1260
R36 avdd.n312 avdd.n95 1260
R37 avdd.n298 avdd.n294 1260
R38 avdd.n354 avdd.n320 1260
R39 avdd.n340 avdd.n336 1260
R40 avdd.n395 avdd.n362 1260
R41 avdd.n381 avdd.n377 1260
R42 avdd.n274 avdd.n97 1260
R43 avdd.n260 avdd.n256 1260
R44 avdd.n434 avdd.n432 1260
R45 avdd.n452 avdd.n451 1260
R46 avdd.n459 avdd.n458 1260
R47 avdd.n477 avdd.n402 1260
R48 avdd.n1202 avdd.n100 1260
R49 avdd.n1184 avdd.n1182 1260
R50 avdd.n1178 avdd.n499 1260
R51 avdd.n516 avdd.n514 1260
R52 avdd.n1159 avdd.n1132 1260
R53 avdd.n1137 avdd.n1132 1260
R54 avdd.n1161 avdd.n102 1260
R55 avdd.n1140 avdd.n102 1260
R56 avdd.n1125 avdd.n524 1260
R57 avdd.n1110 avdd.n1108 1260
R58 avdd.n1103 avdd.n542 1260
R59 avdd.n1004 avdd.n1003 1260
R60 avdd.n812 avdd.n776 1260
R61 avdd.n794 avdd.n793 1260
R62 avdd.n817 avdd.n774 1260
R63 avdd.n761 avdd.n759 1260
R64 avdd.n860 avdd.n856 1260
R65 avdd.n842 avdd.n841 1260
R66 avdd.n739 avdd.n732 1260
R67 avdd.n721 avdd.n720 1260
R68 avdd.n900 avdd.n893 1260
R69 avdd.n882 avdd.n881 1260
R70 avdd.n941 avdd.n937 1260
R71 avdd.n923 avdd.n922 1260
R72 avdd.n981 avdd.n977 1260
R73 avdd.n963 avdd.n962 1260
R74 avdd.n617 avdd.n610 1260
R75 avdd.n599 avdd.n598 1260
R76 avdd.n658 avdd.n651 1260
R77 avdd.n640 avdd.n639 1260
R78 avdd.n699 avdd.n695 1260
R79 avdd.n681 avdd.n680 1260
R80 avdd.n577 avdd.n570 1260
R81 avdd.n559 avdd.n558 1260
R82 avdd.n1080 avdd.n1044 1260
R83 avdd.n1062 avdd.n1061 1260
R84 avdd.n1085 avdd.n1042 1260
R85 avdd.n1029 avdd.n1027 1260
R86 avdd.n1243 avdd.n1209 1260
R87 avdd.n1229 avdd.n1225 1260
R88 avdd.n1282 avdd.n1248 1260
R89 avdd.n1268 avdd.n1264 1260
R90 avdd.n1321 avdd.n1288 1260
R91 avdd.n1307 avdd.n1303 1260
R92 avdd.n236 avdd.n119 1260
R93 avdd.n222 avdd.n218 1260
R94 avdd.n1350 avdd.n120 1260
R95 avdd.n1337 avdd.n1333 1260
R96 avdd.n1141 avdd.n1129 762.354
R97 avdd.n1142 avdd.n1141 762.354
R98 avdd.n1146 avdd.n1145 762.354
R99 avdd.n1146 avdd.n1138 762.354
R100 avdd.n1156 avdd.n1133 762.354
R101 avdd.n1156 avdd.n1155 762.354
R102 avdd.n153 avdd.n151 702.354
R103 avdd.n153 avdd.n147 702.354
R104 avdd.n150 avdd.n149 702.354
R105 avdd.n149 avdd.n145 702.354
R106 avdd.n169 avdd.n141 702.354
R107 avdd.n169 avdd.n140 702.354
R108 avdd.n185 avdd.n137 702.354
R109 avdd.n185 avdd.n132 702.354
R110 avdd.n127 avdd.n126 702.354
R111 avdd.n126 avdd.n123 702.354
R112 avdd.n131 avdd.n129 702.354
R113 avdd.n191 avdd.n131 702.354
R114 avdd.n281 avdd.n280 702.354
R115 avdd.n280 avdd.n278 702.354
R116 avdd.n292 avdd.n291 702.354
R117 avdd.n292 avdd.n286 702.354
R118 avdd.n285 avdd.n283 702.354
R119 avdd.n304 avdd.n285 702.354
R120 avdd.n323 avdd.n322 702.354
R121 avdd.n322 avdd.n318 702.354
R122 avdd.n334 avdd.n333 702.354
R123 avdd.n334 avdd.n328 702.354
R124 avdd.n327 avdd.n325 702.354
R125 avdd.n346 avdd.n327 702.354
R126 avdd.n365 avdd.n364 702.354
R127 avdd.n364 avdd.n360 702.354
R128 avdd.n375 avdd.n374 702.354
R129 avdd.n375 avdd.n370 702.354
R130 avdd.n369 avdd.n367 702.354
R131 avdd.n387 avdd.n369 702.354
R132 avdd.n243 avdd.n242 702.354
R133 avdd.n242 avdd.n240 702.354
R134 avdd.n254 avdd.n253 702.354
R135 avdd.n254 avdd.n248 702.354
R136 avdd.n247 avdd.n245 702.354
R137 avdd.n266 avdd.n247 702.354
R138 avdd.n431 avdd.n429 702.354
R139 avdd.n431 avdd.n425 702.354
R140 avdd.n428 avdd.n427 702.354
R141 avdd.n427 avdd.n423 702.354
R142 avdd.n447 avdd.n419 702.354
R143 avdd.n447 avdd.n418 702.354
R144 avdd.n463 avdd.n415 702.354
R145 avdd.n463 avdd.n410 702.354
R146 avdd.n405 avdd.n404 702.354
R147 avdd.n404 avdd.n400 702.354
R148 avdd.n409 avdd.n407 702.354
R149 avdd.n469 avdd.n409 702.354
R150 avdd.n485 avdd.n484 702.354
R151 avdd.n484 avdd.n482 702.354
R152 avdd.n489 avdd.n487 702.354
R153 avdd.n1194 avdd.n489 702.354
R154 avdd.n1188 avdd.n494 702.354
R155 avdd.n1188 avdd.n490 702.354
R156 avdd.n1175 avdd.n1174 702.354
R157 avdd.n1174 avdd.n498 702.354
R158 avdd.n511 avdd.n504 702.354
R159 avdd.n511 avdd.n508 702.354
R160 avdd.n509 avdd.n505 702.354
R161 avdd.n510 avdd.n509 702.354
R162 avdd.n539 avdd.n536 702.354
R163 avdd.n539 avdd.n538 702.354
R164 avdd.n1000 avdd.n993 702.354
R165 avdd.n1000 avdd.n998 702.354
R166 avdd.n1009 avdd.n995 702.354
R167 avdd.n1009 avdd.n999 702.354
R168 avdd.n1100 avdd.n545 702.354
R169 avdd.n1100 avdd.n544 702.354
R170 avdd.n790 avdd.n783 702.354
R171 avdd.n790 avdd.n788 702.354
R172 avdd.n799 avdd.n785 702.354
R173 avdd.n799 avdd.n789 702.354
R174 avdd.n809 avdd.n779 702.354
R175 avdd.n809 avdd.n778 702.354
R176 avdd.n820 avdd.n771 702.354
R177 avdd.n771 avdd.n769 702.354
R178 avdd.n757 avdd.n751 702.354
R179 avdd.n757 avdd.n755 702.354
R180 avdd.n766 avdd.n752 702.354
R181 avdd.n766 avdd.n756 702.354
R182 avdd.n838 avdd.n832 702.354
R183 avdd.n838 avdd.n836 702.354
R184 avdd.n847 avdd.n833 702.354
R185 avdd.n847 avdd.n837 702.354
R186 avdd.n853 avdd.n852 702.354
R187 avdd.n853 avdd.n850 702.354
R188 avdd.n717 avdd.n711 702.354
R189 avdd.n717 avdd.n715 702.354
R190 avdd.n726 avdd.n712 702.354
R191 avdd.n726 avdd.n716 702.354
R192 avdd.n740 avdd.n731 702.354
R193 avdd.n731 avdd.n729 702.354
R194 avdd.n878 avdd.n872 702.354
R195 avdd.n878 avdd.n876 702.354
R196 avdd.n887 avdd.n873 702.354
R197 avdd.n887 avdd.n877 702.354
R198 avdd.n901 avdd.n892 702.354
R199 avdd.n892 avdd.n890 702.354
R200 avdd.n919 avdd.n913 702.354
R201 avdd.n919 avdd.n917 702.354
R202 avdd.n928 avdd.n914 702.354
R203 avdd.n928 avdd.n918 702.354
R204 avdd.n934 avdd.n933 702.354
R205 avdd.n934 avdd.n931 702.354
R206 avdd.n959 avdd.n953 702.354
R207 avdd.n959 avdd.n957 702.354
R208 avdd.n968 avdd.n954 702.354
R209 avdd.n968 avdd.n958 702.354
R210 avdd.n974 avdd.n973 702.354
R211 avdd.n974 avdd.n971 702.354
R212 avdd.n595 avdd.n589 702.354
R213 avdd.n595 avdd.n593 702.354
R214 avdd.n604 avdd.n590 702.354
R215 avdd.n604 avdd.n594 702.354
R216 avdd.n618 avdd.n609 702.354
R217 avdd.n609 avdd.n607 702.354
R218 avdd.n636 avdd.n630 702.354
R219 avdd.n636 avdd.n634 702.354
R220 avdd.n645 avdd.n631 702.354
R221 avdd.n645 avdd.n635 702.354
R222 avdd.n659 avdd.n650 702.354
R223 avdd.n650 avdd.n648 702.354
R224 avdd.n677 avdd.n671 702.354
R225 avdd.n677 avdd.n675 702.354
R226 avdd.n686 avdd.n672 702.354
R227 avdd.n686 avdd.n676 702.354
R228 avdd.n692 avdd.n691 702.354
R229 avdd.n692 avdd.n689 702.354
R230 avdd.n555 avdd.n549 702.354
R231 avdd.n555 avdd.n553 702.354
R232 avdd.n564 avdd.n550 702.354
R233 avdd.n564 avdd.n554 702.354
R234 avdd.n578 avdd.n569 702.354
R235 avdd.n569 avdd.n567 702.354
R236 avdd.n1058 avdd.n1051 702.354
R237 avdd.n1058 avdd.n1056 702.354
R238 avdd.n1067 avdd.n1053 702.354
R239 avdd.n1067 avdd.n1057 702.354
R240 avdd.n1077 avdd.n1047 702.354
R241 avdd.n1077 avdd.n1046 702.354
R242 avdd.n1088 avdd.n1039 702.354
R243 avdd.n1039 avdd.n1037 702.354
R244 avdd.n1025 avdd.n1019 702.354
R245 avdd.n1025 avdd.n1023 702.354
R246 avdd.n1034 avdd.n1020 702.354
R247 avdd.n1034 avdd.n1024 702.354
R248 avdd.n533 avdd.n532 702.354
R249 avdd.n533 avdd.n530 702.354
R250 avdd.n527 avdd.n523 702.354
R251 avdd.n527 avdd.n526 702.354
R252 avdd.n1212 avdd.n1211 702.354
R253 avdd.n1211 avdd.n1207 702.354
R254 avdd.n1223 avdd.n1222 702.354
R255 avdd.n1223 avdd.n1217 702.354
R256 avdd.n1216 avdd.n1214 702.354
R257 avdd.n1235 avdd.n1216 702.354
R258 avdd.n1251 avdd.n1250 702.354
R259 avdd.n1250 avdd.n1247 702.354
R260 avdd.n1262 avdd.n1261 702.354
R261 avdd.n1262 avdd.n1256 702.354
R262 avdd.n1255 avdd.n1253 702.354
R263 avdd.n1274 avdd.n1255 702.354
R264 avdd.n1291 avdd.n1290 702.354
R265 avdd.n1290 avdd.n1287 702.354
R266 avdd.n1301 avdd.n1300 702.354
R267 avdd.n1301 avdd.n1296 702.354
R268 avdd.n1295 avdd.n1293 702.354
R269 avdd.n1313 avdd.n1295 702.354
R270 avdd.n205 avdd.n204 702.354
R271 avdd.n204 avdd.n202 702.354
R272 avdd.n216 avdd.n215 702.354
R273 avdd.n216 avdd.n210 702.354
R274 avdd.n209 avdd.n207 702.354
R275 avdd.n228 avdd.n209 702.354
R276 avdd.n1346 avdd.n1343 702.354
R277 avdd.n1346 avdd.n1345 702.354
R278 avdd.n1330 avdd.n1328 702.354
R279 avdd.n1330 avdd.n1324 702.354
R280 avdd.n1340 avdd.n1329 702.354
R281 avdd.n1340 avdd.n1325 702.354
R282 avdd.n277 avdd.t158 659.926
R283 avdd.n316 avdd.t110 659.926
R284 avdd.n358 avdd.t152 659.926
R285 avdd.n239 avdd.t48 659.926
R286 avdd.n18 avdd.t10 659.926
R287 avdd.n398 avdd.t106 659.926
R288 avdd.n481 avdd.t137 659.926
R289 avdd.n1173 avdd.t8 659.926
R290 avdd.n521 avdd.t57 659.926
R291 avdd.n540 avdd.t169 659.926
R292 avdd.n1001 avdd.t18 659.926
R293 avdd.n791 avdd.t24 659.926
R294 avdd.n758 avdd.t174 659.926
R295 avdd.n839 avdd.t42 659.926
R296 avdd.n718 avdd.t45 659.926
R297 avdd.n879 avdd.t155 659.926
R298 avdd.n920 avdd.t35 659.926
R299 avdd.n960 avdd.t21 659.926
R300 avdd.n596 avdd.t61 659.926
R301 avdd.n637 avdd.t4 659.926
R302 avdd.n678 avdd.t66 659.926
R303 avdd.n556 avdd.t14 659.926
R304 avdd.n1059 avdd.t69 659.926
R305 avdd.n1026 avdd.t135 659.926
R306 avdd.n1205 avdd.t54 659.926
R307 avdd.n319 avdd.t122 656.437
R308 avdd.n361 avdd.t74 656.437
R309 avdd.n401 avdd.t116 656.437
R310 avdd.n496 avdd.t180 656.437
R311 avdd.n1208 avdd.t90 656.437
R312 avdd.n1109 avdd.t182 643.525
R313 avdd.n96 avdd.t104 642.245
R314 avdd.n98 avdd.t98 642.245
R315 avdd.n99 avdd.t144 642.245
R316 avdd.n101 avdd.t94 642.245
R317 avdd.n104 avdd.t140 642.245
R318 avdd.n105 avdd.t78 642.245
R319 avdd.n106 avdd.t148 642.245
R320 avdd.n107 avdd.t126 642.245
R321 avdd.n108 avdd.t100 642.245
R322 avdd.n109 avdd.t102 642.245
R323 avdd.n110 avdd.t124 642.245
R324 avdd.n111 avdd.t96 642.245
R325 avdd.n112 avdd.t92 642.245
R326 avdd.n113 avdd.t82 642.245
R327 avdd.n114 avdd.t112 642.245
R328 avdd.n115 avdd.t86 642.245
R329 avdd.n116 avdd.t76 642.245
R330 avdd.n117 avdd.t146 642.245
R331 avdd.n118 avdd.t120 642.245
R332 avdd.n158 avdd.n151 557.648
R333 avdd.n162 avdd.n151 557.648
R334 avdd.n162 avdd.n150 557.648
R335 avdd.n150 avdd.n144 557.648
R336 avdd.n144 avdd.n141 557.648
R337 avdd.n173 avdd.n141 557.648
R338 avdd.n156 avdd.n147 557.648
R339 avdd.n163 avdd.n147 557.648
R340 avdd.n163 avdd.n145 557.648
R341 avdd.n167 avdd.n145 557.648
R342 avdd.n167 avdd.n140 557.648
R343 avdd.n176 avdd.n140 557.648
R344 avdd.n197 avdd.n127 557.648
R345 avdd.n193 avdd.n127 557.648
R346 avdd.n193 avdd.n129 557.648
R347 avdd.n189 avdd.n129 557.648
R348 avdd.n189 avdd.n137 557.648
R349 avdd.n181 avdd.n137 557.648
R350 avdd.n199 avdd.n123 557.648
R351 avdd.n192 avdd.n123 557.648
R352 avdd.n192 avdd.n191 557.648
R353 avdd.n191 avdd.n190 557.648
R354 avdd.n190 avdd.n132 557.648
R355 avdd.n183 avdd.n132 557.648
R356 avdd.n310 avdd.n281 557.648
R357 avdd.n306 avdd.n281 557.648
R358 avdd.n306 avdd.n283 557.648
R359 avdd.n302 avdd.n283 557.648
R360 avdd.n302 avdd.n291 557.648
R361 avdd.n298 avdd.n291 557.648
R362 avdd.n312 avdd.n278 557.648
R363 avdd.n305 avdd.n278 557.648
R364 avdd.n305 avdd.n304 557.648
R365 avdd.n304 avdd.n303 557.648
R366 avdd.n303 avdd.n286 557.648
R367 avdd.n296 avdd.n286 557.648
R368 avdd.n352 avdd.n323 557.648
R369 avdd.n348 avdd.n323 557.648
R370 avdd.n348 avdd.n325 557.648
R371 avdd.n344 avdd.n325 557.648
R372 avdd.n344 avdd.n333 557.648
R373 avdd.n340 avdd.n333 557.648
R374 avdd.n354 avdd.n318 557.648
R375 avdd.n347 avdd.n318 557.648
R376 avdd.n347 avdd.n346 557.648
R377 avdd.n346 avdd.n345 557.648
R378 avdd.n345 avdd.n328 557.648
R379 avdd.n338 avdd.n328 557.648
R380 avdd.n393 avdd.n365 557.648
R381 avdd.n389 avdd.n365 557.648
R382 avdd.n389 avdd.n367 557.648
R383 avdd.n385 avdd.n367 557.648
R384 avdd.n385 avdd.n374 557.648
R385 avdd.n381 avdd.n374 557.648
R386 avdd.n395 avdd.n360 557.648
R387 avdd.n388 avdd.n360 557.648
R388 avdd.n388 avdd.n387 557.648
R389 avdd.n387 avdd.n386 557.648
R390 avdd.n386 avdd.n370 557.648
R391 avdd.n379 avdd.n370 557.648
R392 avdd.n272 avdd.n243 557.648
R393 avdd.n268 avdd.n243 557.648
R394 avdd.n268 avdd.n245 557.648
R395 avdd.n264 avdd.n245 557.648
R396 avdd.n264 avdd.n253 557.648
R397 avdd.n260 avdd.n253 557.648
R398 avdd.n274 avdd.n240 557.648
R399 avdd.n267 avdd.n240 557.648
R400 avdd.n267 avdd.n266 557.648
R401 avdd.n266 avdd.n265 557.648
R402 avdd.n265 avdd.n248 557.648
R403 avdd.n258 avdd.n248 557.648
R404 avdd.n436 avdd.n429 557.648
R405 avdd.n440 avdd.n429 557.648
R406 avdd.n440 avdd.n428 557.648
R407 avdd.n428 avdd.n422 557.648
R408 avdd.n422 avdd.n419 557.648
R409 avdd.n451 avdd.n419 557.648
R410 avdd.n434 avdd.n425 557.648
R411 avdd.n441 avdd.n425 557.648
R412 avdd.n441 avdd.n423 557.648
R413 avdd.n445 avdd.n423 557.648
R414 avdd.n445 avdd.n418 557.648
R415 avdd.n454 avdd.n418 557.648
R416 avdd.n475 avdd.n405 557.648
R417 avdd.n471 avdd.n405 557.648
R418 avdd.n471 avdd.n407 557.648
R419 avdd.n467 avdd.n407 557.648
R420 avdd.n467 avdd.n415 557.648
R421 avdd.n459 avdd.n415 557.648
R422 avdd.n477 avdd.n400 557.648
R423 avdd.n470 avdd.n400 557.648
R424 avdd.n470 avdd.n469 557.648
R425 avdd.n469 avdd.n468 557.648
R426 avdd.n468 avdd.n410 557.648
R427 avdd.n461 avdd.n410 557.648
R428 avdd.n1200 avdd.n485 557.648
R429 avdd.n1196 avdd.n485 557.648
R430 avdd.n1196 avdd.n487 557.648
R431 avdd.n1192 avdd.n487 557.648
R432 avdd.n1192 avdd.n494 557.648
R433 avdd.n1182 avdd.n494 557.648
R434 avdd.n1202 avdd.n482 557.648
R435 avdd.n1195 avdd.n482 557.648
R436 avdd.n1195 avdd.n1194 557.648
R437 avdd.n1194 avdd.n1193 557.648
R438 avdd.n1193 avdd.n490 557.648
R439 avdd.n1186 avdd.n490 557.648
R440 avdd.n1176 avdd.n1175 557.648
R441 avdd.n1175 avdd.n501 557.648
R442 avdd.n505 avdd.n501 557.648
R443 avdd.n1168 avdd.n505 557.648
R444 avdd.n1168 avdd.n504 557.648
R445 avdd.n516 avdd.n504 557.648
R446 avdd.n1178 avdd.n498 557.648
R447 avdd.n1163 avdd.n498 557.648
R448 avdd.n1163 avdd.n510 557.648
R449 avdd.n1167 avdd.n510 557.648
R450 avdd.n1167 avdd.n508 557.648
R451 avdd.n518 avdd.n508 557.648
R452 avdd.n1127 avdd.n523 557.648
R453 avdd.n1120 avdd.n523 557.648
R454 avdd.n1120 avdd.n532 557.648
R455 avdd.n1117 avdd.n532 557.648
R456 avdd.n1117 avdd.n536 557.648
R457 avdd.n1108 avdd.n536 557.648
R458 avdd.n1125 avdd.n526 557.648
R459 avdd.n1121 avdd.n526 557.648
R460 avdd.n1121 avdd.n530 557.648
R461 avdd.n1116 avdd.n530 557.648
R462 avdd.n1116 avdd.n538 557.648
R463 avdd.n1112 avdd.n538 557.648
R464 avdd.n545 avdd.n543 557.648
R465 avdd.n994 avdd.n545 557.648
R466 avdd.n995 avdd.n994 557.648
R467 avdd.n1016 avdd.n995 557.648
R468 avdd.n1016 avdd.n993 557.648
R469 avdd.n1003 avdd.n993 557.648
R470 avdd.n544 avdd.n542 557.648
R471 avdd.n1011 avdd.n544 557.648
R472 avdd.n1011 avdd.n999 557.648
R473 avdd.n1015 avdd.n999 557.648
R474 avdd.n1015 avdd.n998 557.648
R475 avdd.n1006 avdd.n998 557.648
R476 avdd.n779 avdd.n777 557.648
R477 avdd.n784 avdd.n779 557.648
R478 avdd.n785 avdd.n784 557.648
R479 avdd.n806 avdd.n785 557.648
R480 avdd.n806 avdd.n783 557.648
R481 avdd.n793 avdd.n783 557.648
R482 avdd.n778 avdd.n776 557.648
R483 avdd.n801 avdd.n778 557.648
R484 avdd.n801 avdd.n789 557.648
R485 avdd.n805 avdd.n789 557.648
R486 avdd.n805 avdd.n788 557.648
R487 avdd.n796 avdd.n788 557.648
R488 avdd.n820 avdd.n819 557.648
R489 avdd.n822 avdd.n820 557.648
R490 avdd.n822 avdd.n752 557.648
R491 avdd.n828 avdd.n752 557.648
R492 avdd.n828 avdd.n751 557.648
R493 avdd.n761 avdd.n751 557.648
R494 avdd.n817 avdd.n769 557.648
R495 avdd.n823 avdd.n769 557.648
R496 avdd.n823 avdd.n756 557.648
R497 avdd.n827 avdd.n756 557.648
R498 avdd.n827 avdd.n755 557.648
R499 avdd.n763 avdd.n755 557.648
R500 avdd.n860 avdd.n852 557.648
R501 avdd.n863 avdd.n852 557.648
R502 avdd.n863 avdd.n833 557.648
R503 avdd.n869 avdd.n833 557.648
R504 avdd.n869 avdd.n832 557.648
R505 avdd.n841 avdd.n832 557.648
R506 avdd.n858 avdd.n850 557.648
R507 avdd.n864 avdd.n850 557.648
R508 avdd.n864 avdd.n837 557.648
R509 avdd.n868 avdd.n837 557.648
R510 avdd.n868 avdd.n836 557.648
R511 avdd.n844 avdd.n836 557.648
R512 avdd.n740 avdd.n739 557.648
R513 avdd.n742 avdd.n740 557.648
R514 avdd.n742 avdd.n712 557.648
R515 avdd.n748 avdd.n712 557.648
R516 avdd.n748 avdd.n711 557.648
R517 avdd.n720 avdd.n711 557.648
R518 avdd.n737 avdd.n729 557.648
R519 avdd.n743 avdd.n729 557.648
R520 avdd.n743 avdd.n716 557.648
R521 avdd.n747 avdd.n716 557.648
R522 avdd.n747 avdd.n715 557.648
R523 avdd.n723 avdd.n715 557.648
R524 avdd.n901 avdd.n900 557.648
R525 avdd.n903 avdd.n901 557.648
R526 avdd.n903 avdd.n873 557.648
R527 avdd.n909 avdd.n873 557.648
R528 avdd.n909 avdd.n872 557.648
R529 avdd.n881 avdd.n872 557.648
R530 avdd.n898 avdd.n890 557.648
R531 avdd.n904 avdd.n890 557.648
R532 avdd.n904 avdd.n877 557.648
R533 avdd.n908 avdd.n877 557.648
R534 avdd.n908 avdd.n876 557.648
R535 avdd.n884 avdd.n876 557.648
R536 avdd.n941 avdd.n933 557.648
R537 avdd.n944 avdd.n933 557.648
R538 avdd.n944 avdd.n914 557.648
R539 avdd.n950 avdd.n914 557.648
R540 avdd.n950 avdd.n913 557.648
R541 avdd.n922 avdd.n913 557.648
R542 avdd.n939 avdd.n931 557.648
R543 avdd.n945 avdd.n931 557.648
R544 avdd.n945 avdd.n918 557.648
R545 avdd.n949 avdd.n918 557.648
R546 avdd.n949 avdd.n917 557.648
R547 avdd.n925 avdd.n917 557.648
R548 avdd.n981 avdd.n973 557.648
R549 avdd.n984 avdd.n973 557.648
R550 avdd.n984 avdd.n954 557.648
R551 avdd.n990 avdd.n954 557.648
R552 avdd.n990 avdd.n953 557.648
R553 avdd.n962 avdd.n953 557.648
R554 avdd.n979 avdd.n971 557.648
R555 avdd.n985 avdd.n971 557.648
R556 avdd.n985 avdd.n958 557.648
R557 avdd.n989 avdd.n958 557.648
R558 avdd.n989 avdd.n957 557.648
R559 avdd.n965 avdd.n957 557.648
R560 avdd.n618 avdd.n617 557.648
R561 avdd.n620 avdd.n618 557.648
R562 avdd.n620 avdd.n590 557.648
R563 avdd.n626 avdd.n590 557.648
R564 avdd.n626 avdd.n589 557.648
R565 avdd.n598 avdd.n589 557.648
R566 avdd.n615 avdd.n607 557.648
R567 avdd.n621 avdd.n607 557.648
R568 avdd.n621 avdd.n594 557.648
R569 avdd.n625 avdd.n594 557.648
R570 avdd.n625 avdd.n593 557.648
R571 avdd.n601 avdd.n593 557.648
R572 avdd.n659 avdd.n658 557.648
R573 avdd.n661 avdd.n659 557.648
R574 avdd.n661 avdd.n631 557.648
R575 avdd.n667 avdd.n631 557.648
R576 avdd.n667 avdd.n630 557.648
R577 avdd.n639 avdd.n630 557.648
R578 avdd.n656 avdd.n648 557.648
R579 avdd.n662 avdd.n648 557.648
R580 avdd.n662 avdd.n635 557.648
R581 avdd.n666 avdd.n635 557.648
R582 avdd.n666 avdd.n634 557.648
R583 avdd.n642 avdd.n634 557.648
R584 avdd.n699 avdd.n691 557.648
R585 avdd.n702 avdd.n691 557.648
R586 avdd.n702 avdd.n672 557.648
R587 avdd.n708 avdd.n672 557.648
R588 avdd.n708 avdd.n671 557.648
R589 avdd.n680 avdd.n671 557.648
R590 avdd.n697 avdd.n689 557.648
R591 avdd.n703 avdd.n689 557.648
R592 avdd.n703 avdd.n676 557.648
R593 avdd.n707 avdd.n676 557.648
R594 avdd.n707 avdd.n675 557.648
R595 avdd.n683 avdd.n675 557.648
R596 avdd.n578 avdd.n577 557.648
R597 avdd.n580 avdd.n578 557.648
R598 avdd.n580 avdd.n550 557.648
R599 avdd.n586 avdd.n550 557.648
R600 avdd.n586 avdd.n549 557.648
R601 avdd.n558 avdd.n549 557.648
R602 avdd.n575 avdd.n567 557.648
R603 avdd.n581 avdd.n567 557.648
R604 avdd.n581 avdd.n554 557.648
R605 avdd.n585 avdd.n554 557.648
R606 avdd.n585 avdd.n553 557.648
R607 avdd.n561 avdd.n553 557.648
R608 avdd.n1047 avdd.n1045 557.648
R609 avdd.n1052 avdd.n1047 557.648
R610 avdd.n1053 avdd.n1052 557.648
R611 avdd.n1074 avdd.n1053 557.648
R612 avdd.n1074 avdd.n1051 557.648
R613 avdd.n1061 avdd.n1051 557.648
R614 avdd.n1046 avdd.n1044 557.648
R615 avdd.n1069 avdd.n1046 557.648
R616 avdd.n1069 avdd.n1057 557.648
R617 avdd.n1073 avdd.n1057 557.648
R618 avdd.n1073 avdd.n1056 557.648
R619 avdd.n1064 avdd.n1056 557.648
R620 avdd.n1088 avdd.n1087 557.648
R621 avdd.n1090 avdd.n1088 557.648
R622 avdd.n1090 avdd.n1020 557.648
R623 avdd.n1096 avdd.n1020 557.648
R624 avdd.n1096 avdd.n1019 557.648
R625 avdd.n1029 avdd.n1019 557.648
R626 avdd.n1085 avdd.n1037 557.648
R627 avdd.n1091 avdd.n1037 557.648
R628 avdd.n1091 avdd.n1024 557.648
R629 avdd.n1095 avdd.n1024 557.648
R630 avdd.n1095 avdd.n1023 557.648
R631 avdd.n1031 avdd.n1023 557.648
R632 avdd.n1241 avdd.n1212 557.648
R633 avdd.n1237 avdd.n1212 557.648
R634 avdd.n1237 avdd.n1214 557.648
R635 avdd.n1233 avdd.n1214 557.648
R636 avdd.n1233 avdd.n1222 557.648
R637 avdd.n1229 avdd.n1222 557.648
R638 avdd.n1243 avdd.n1207 557.648
R639 avdd.n1236 avdd.n1207 557.648
R640 avdd.n1236 avdd.n1235 557.648
R641 avdd.n1235 avdd.n1234 557.648
R642 avdd.n1234 avdd.n1217 557.648
R643 avdd.n1227 avdd.n1217 557.648
R644 avdd.n1280 avdd.n1251 557.648
R645 avdd.n1276 avdd.n1251 557.648
R646 avdd.n1276 avdd.n1253 557.648
R647 avdd.n1272 avdd.n1253 557.648
R648 avdd.n1272 avdd.n1261 557.648
R649 avdd.n1268 avdd.n1261 557.648
R650 avdd.n1282 avdd.n1247 557.648
R651 avdd.n1275 avdd.n1247 557.648
R652 avdd.n1275 avdd.n1274 557.648
R653 avdd.n1274 avdd.n1273 557.648
R654 avdd.n1273 avdd.n1256 557.648
R655 avdd.n1266 avdd.n1256 557.648
R656 avdd.n1319 avdd.n1291 557.648
R657 avdd.n1315 avdd.n1291 557.648
R658 avdd.n1315 avdd.n1293 557.648
R659 avdd.n1311 avdd.n1293 557.648
R660 avdd.n1311 avdd.n1300 557.648
R661 avdd.n1307 avdd.n1300 557.648
R662 avdd.n1321 avdd.n1287 557.648
R663 avdd.n1314 avdd.n1287 557.648
R664 avdd.n1314 avdd.n1313 557.648
R665 avdd.n1313 avdd.n1312 557.648
R666 avdd.n1312 avdd.n1296 557.648
R667 avdd.n1305 avdd.n1296 557.648
R668 avdd.n234 avdd.n205 557.648
R669 avdd.n230 avdd.n205 557.648
R670 avdd.n230 avdd.n207 557.648
R671 avdd.n226 avdd.n207 557.648
R672 avdd.n226 avdd.n215 557.648
R673 avdd.n222 avdd.n215 557.648
R674 avdd.n236 avdd.n202 557.648
R675 avdd.n229 avdd.n202 557.648
R676 avdd.n229 avdd.n228 557.648
R677 avdd.n228 avdd.n227 557.648
R678 avdd.n227 avdd.n210 557.648
R679 avdd.n220 avdd.n210 557.648
R680 avdd.n1348 avdd.n1343 557.648
R681 avdd.n1354 avdd.n1343 557.648
R682 avdd.n1354 avdd.n1329 557.648
R683 avdd.n1358 avdd.n1329 557.648
R684 avdd.n1358 avdd.n1328 557.648
R685 avdd.n1337 avdd.n1328 557.648
R686 avdd.n1350 avdd.n1345 557.648
R687 avdd.n1353 avdd.n1345 557.648
R688 avdd.n1353 avdd.n1325 557.648
R689 avdd.n1359 avdd.n1325 557.648
R690 avdd.n1359 avdd.n1324 557.648
R691 avdd.n1335 avdd.n1324 557.648
R692 avdd.n1161 avdd.n1129 497.647
R693 avdd.n1131 avdd.n1129 497.647
R694 avdd.n1145 avdd.n1131 497.647
R695 avdd.n1152 avdd.n1142 497.647
R696 avdd.n1152 avdd.n1138 497.647
R697 avdd.n1154 avdd.n1138 497.647
R698 avdd.n1155 avdd.n1154 497.647
R699 avdd.n1145 avdd.n1130 497.647
R700 avdd.n1133 avdd.n1130 497.647
R701 avdd.n1159 avdd.n1133 497.647
R702 avdd.n1155 avdd.n1137 497.647
R703 avdd.n1142 avdd.n1140 497.647
R704 avdd.n93 avdd.n92 0.72689
R705 avdd.t141 avdd.n148 278.997
R706 avdd.t149 avdd.n148 278.997
R707 avdd.t149 avdd.n143 278.997
R708 avdd.t178 avdd.n143 278.997
R709 avdd.n168 avdd.t178 278.997
R710 avdd.n168 avdd.t128 278.997
R711 avdd.t117 avdd.n125 278.997
R712 avdd.t37 avdd.n125 278.997
R713 avdd.t37 avdd.n130 278.997
R714 avdd.t156 avdd.n130 278.997
R715 avdd.t156 avdd.n136 278.997
R716 avdd.t1 avdd.n136 278.997
R717 avdd.t103 avdd.n279 278.997
R718 avdd.t157 avdd.n279 278.997
R719 avdd.t157 avdd.n284 278.997
R720 avdd.t58 avdd.n284 278.997
R721 avdd.t58 avdd.n290 278.997
R722 avdd.t163 avdd.n290 278.997
R723 avdd.t121 avdd.n321 278.997
R724 avdd.t109 avdd.n321 278.997
R725 avdd.t109 avdd.n326 278.997
R726 avdd.t177 avdd.n326 278.997
R727 avdd.t177 avdd.n332 278.997
R728 avdd.t171 avdd.n332 278.997
R729 avdd.t73 avdd.n363 278.997
R730 avdd.t151 avdd.n363 278.997
R731 avdd.t151 avdd.n368 278.997
R732 avdd.t0 avdd.n368 278.997
R733 avdd.t0 avdd.n373 278.997
R734 avdd.t29 avdd.n373 278.997
R735 avdd.t97 avdd.n241 278.997
R736 avdd.t47 avdd.n241 278.997
R737 avdd.t47 avdd.n246 278.997
R738 avdd.t165 avdd.n246 278.997
R739 avdd.t165 avdd.n252 278.997
R740 avdd.t107 avdd.n252 278.997
R741 avdd.t143 avdd.n426 278.997
R742 avdd.t9 avdd.n426 278.997
R743 avdd.t9 avdd.n421 278.997
R744 avdd.t164 avdd.n421 278.997
R745 avdd.n446 avdd.t164 278.997
R746 avdd.n446 avdd.t6 278.997
R747 avdd.t115 avdd.n403 278.997
R748 avdd.t105 avdd.n403 278.997
R749 avdd.t105 avdd.n408 278.997
R750 avdd.t127 avdd.n408 278.997
R751 avdd.t127 avdd.n414 278.997
R752 avdd.t31 avdd.n414 278.997
R753 avdd.t93 avdd.n483 278.997
R754 avdd.t136 avdd.n483 278.997
R755 avdd.t136 avdd.n488 278.997
R756 avdd.t36 avdd.n488 278.997
R757 avdd.t36 avdd.n493 278.997
R758 avdd.t49 avdd.n493 278.997
R759 avdd.t179 avdd.n500 278.997
R760 avdd.t7 avdd.n500 278.997
R761 avdd.t7 avdd.n507 278.997
R762 avdd.t139 avdd.n507 278.997
R763 avdd.t139 avdd.n506 278.997
R764 avdd.t15 avdd.n506 278.997
R765 avdd.t166 avdd.n1101 278.997
R766 avdd.n1101 avdd.t16 278.997
R767 avdd.n997 avdd.t16 278.997
R768 avdd.t17 avdd.n997 278.997
R769 avdd.t17 avdd.n996 278.997
R770 avdd.t77 avdd.n996 278.997
R771 avdd.t63 avdd.n810 278.997
R772 avdd.n810 avdd.t22 278.997
R773 avdd.n787 avdd.t22 278.997
R774 avdd.t23 avdd.n787 278.997
R775 avdd.t23 avdd.n786 278.997
R776 avdd.t147 avdd.n786 278.997
R777 avdd.t39 avdd.n770 278.997
R778 avdd.t172 avdd.n770 278.997
R779 avdd.t172 avdd.n754 278.997
R780 avdd.t173 avdd.n754 278.997
R781 avdd.t173 avdd.n753 278.997
R782 avdd.t125 avdd.n753 278.997
R783 avdd.t50 avdd.n851 278.997
R784 avdd.t40 avdd.n851 278.997
R785 avdd.t40 avdd.n835 278.997
R786 avdd.t41 avdd.n835 278.997
R787 avdd.t41 avdd.n834 278.997
R788 avdd.t99 avdd.n834 278.997
R789 avdd.t5 avdd.n730 278.997
R790 avdd.t43 avdd.n730 278.997
R791 avdd.t43 avdd.n714 278.997
R792 avdd.t44 avdd.n714 278.997
R793 avdd.t44 avdd.n713 278.997
R794 avdd.t101 avdd.n713 278.997
R795 avdd.t32 avdd.n891 278.997
R796 avdd.t153 avdd.n891 278.997
R797 avdd.t153 avdd.n875 278.997
R798 avdd.t154 avdd.n875 278.997
R799 avdd.t154 avdd.n874 278.997
R800 avdd.t123 avdd.n874 278.997
R801 avdd.t170 avdd.n932 278.997
R802 avdd.t33 avdd.n932 278.997
R803 avdd.t33 avdd.n916 278.997
R804 avdd.t34 avdd.n916 278.997
R805 avdd.t34 avdd.n915 278.997
R806 avdd.t95 avdd.n915 278.997
R807 avdd.t27 avdd.n972 278.997
R808 avdd.t19 avdd.n972 278.997
R809 avdd.t19 avdd.n956 278.997
R810 avdd.t20 avdd.n956 278.997
R811 avdd.t20 avdd.n955 278.997
R812 avdd.t91 avdd.n955 278.997
R813 avdd.t138 avdd.n608 278.997
R814 avdd.t59 avdd.n608 278.997
R815 avdd.t59 avdd.n592 278.997
R816 avdd.t60 avdd.n592 278.997
R817 avdd.t60 avdd.n591 278.997
R818 avdd.t81 avdd.n591 278.997
R819 avdd.t30 avdd.n649 278.997
R820 avdd.t2 avdd.n649 278.997
R821 avdd.t2 avdd.n633 278.997
R822 avdd.t3 avdd.n633 278.997
R823 avdd.t3 avdd.n632 278.997
R824 avdd.t111 avdd.n632 278.997
R825 avdd.t161 avdd.n690 278.997
R826 avdd.t64 avdd.n690 278.997
R827 avdd.t64 avdd.n674 278.997
R828 avdd.t65 avdd.n674 278.997
R829 avdd.t65 avdd.n673 278.997
R830 avdd.t85 avdd.n673 278.997
R831 avdd.t11 avdd.n568 278.997
R832 avdd.t12 avdd.n568 278.997
R833 avdd.t12 avdd.n552 278.997
R834 avdd.t13 avdd.n552 278.997
R835 avdd.t13 avdd.n551 278.997
R836 avdd.t75 avdd.n551 278.997
R837 avdd.t25 avdd.n1078 278.997
R838 avdd.n1078 avdd.t67 278.997
R839 avdd.n1055 avdd.t67 278.997
R840 avdd.t68 avdd.n1055 278.997
R841 avdd.t68 avdd.n1054 278.997
R842 avdd.t145 avdd.n1054 278.997
R843 avdd.t62 avdd.n1038 278.997
R844 avdd.t133 avdd.n1038 278.997
R845 avdd.t133 avdd.n1022 278.997
R846 avdd.t134 avdd.n1022 278.997
R847 avdd.t134 avdd.n1021 278.997
R848 avdd.t119 avdd.n1021 278.997
R849 avdd.t130 avdd.n525 278.997
R850 avdd.t167 avdd.n525 278.997
R851 avdd.t167 avdd.n531 278.997
R852 avdd.t168 avdd.n531 278.997
R853 avdd.t168 avdd.n537 278.997
R854 avdd.t181 avdd.n537 278.997
R855 avdd.t89 avdd.n1210 278.997
R856 avdd.t53 avdd.n1210 278.997
R857 avdd.t53 avdd.n1215 278.997
R858 avdd.t46 avdd.n1215 278.997
R859 avdd.t46 avdd.n1221 278.997
R860 avdd.t26 avdd.n1221 278.997
R861 avdd.t113 avdd.n1249 278.997
R862 avdd.t175 avdd.n1249 278.997
R863 avdd.t175 avdd.n1254 278.997
R864 avdd.t51 avdd.n1254 278.997
R865 avdd.t51 avdd.n1260 278.997
R866 avdd.t162 avdd.n1260 278.997
R867 avdd.t87 avdd.n1289 278.997
R868 avdd.t70 avdd.n1289 278.997
R869 avdd.t70 avdd.n1294 278.997
R870 avdd.t129 avdd.n1294 278.997
R871 avdd.t129 avdd.n1299 278.997
R872 avdd.t108 avdd.n1299 278.997
R873 avdd.t83 avdd.n203 278.997
R874 avdd.t131 avdd.n203 278.997
R875 avdd.t131 avdd.n208 278.997
R876 avdd.t52 avdd.n208 278.997
R877 avdd.t52 avdd.n214 278.997
R878 avdd.t28 avdd.n214 278.997
R879 avdd.t79 avdd.n1344 278.997
R880 avdd.t159 avdd.n1344 278.997
R881 avdd.t159 avdd.n1327 278.997
R882 avdd.t72 avdd.n1327 278.997
R883 avdd.t72 avdd.n1326 278.997
R884 avdd.t55 avdd.n1326 278.997
R885 avdd.n1180 avdd.n497 265.339
R886 avdd.n175 avdd.n174 244.263
R887 avdd.n157 avdd.n154 244.263
R888 avdd.n198 avdd.n124 244.263
R889 avdd.n182 avdd.n180 244.263
R890 avdd.n311 avdd.n95 244.263
R891 avdd.n297 avdd.n294 244.263
R892 avdd.n353 avdd.n320 244.263
R893 avdd.n339 avdd.n336 244.263
R894 avdd.n394 avdd.n362 244.263
R895 avdd.n380 avdd.n377 244.263
R896 avdd.n273 avdd.n97 244.263
R897 avdd.n259 avdd.n256 244.263
R898 avdd.n453 avdd.n452 244.263
R899 avdd.n435 avdd.n432 244.263
R900 avdd.n476 avdd.n402 244.263
R901 avdd.n460 avdd.n458 244.263
R902 avdd.n1185 avdd.n1184 244.263
R903 avdd.n1201 avdd.n100 244.263
R904 avdd.n1177 avdd.n499 244.263
R905 avdd.n517 avdd.n514 244.263
R906 avdd.n1126 avdd.n524 244.263
R907 avdd.n1111 avdd.n1110 244.263
R908 avdd.n1103 avdd.n1102 244.263
R909 avdd.n1005 avdd.n1004 244.263
R910 avdd.n812 avdd.n811 244.263
R911 avdd.n795 avdd.n794 244.263
R912 avdd.n818 avdd.n774 244.263
R913 avdd.n762 avdd.n759 244.263
R914 avdd.n843 avdd.n842 244.263
R915 avdd.n859 avdd.n856 244.263
R916 avdd.n722 avdd.n721 244.263
R917 avdd.n738 avdd.n732 244.263
R918 avdd.n883 avdd.n882 244.263
R919 avdd.n899 avdd.n893 244.263
R920 avdd.n924 avdd.n923 244.263
R921 avdd.n940 avdd.n937 244.263
R922 avdd.n964 avdd.n963 244.263
R923 avdd.n980 avdd.n977 244.263
R924 avdd.n600 avdd.n599 244.263
R925 avdd.n616 avdd.n610 244.263
R926 avdd.n641 avdd.n640 244.263
R927 avdd.n657 avdd.n651 244.263
R928 avdd.n682 avdd.n681 244.263
R929 avdd.n698 avdd.n695 244.263
R930 avdd.n560 avdd.n559 244.263
R931 avdd.n576 avdd.n570 244.263
R932 avdd.n1080 avdd.n1079 244.263
R933 avdd.n1063 avdd.n1062 244.263
R934 avdd.n1086 avdd.n1042 244.263
R935 avdd.n1030 avdd.n1027 244.263
R936 avdd.n1242 avdd.n1209 244.263
R937 avdd.n1228 avdd.n1225 244.263
R938 avdd.n1281 avdd.n1248 244.263
R939 avdd.n1267 avdd.n1264 244.263
R940 avdd.n1320 avdd.n1288 244.263
R941 avdd.n1306 avdd.n1303 244.263
R942 avdd.n235 avdd.n119 244.263
R943 avdd.n221 avdd.n218 244.263
R944 avdd.n1349 avdd.n120 244.263
R945 avdd.n1336 avdd.n1333 244.263
R946 avdd.n1181 avdd.n1180 197.464
R947 avdd.n1180 avdd.n1179 158.752
R948 avdd.n1160 avdd.t56 149.781
R949 avdd.n1153 avdd.t56 149.781
R950 avdd.n103 avdd.n1128 146.358
R951 avdd.n1106 avdd.n1105 109.504
R952 avdd.n341 avdd.n335 102.713
R953 avdd.n382 avdd.n376 102.713
R954 avdd.n515 avdd.n513 102.713
R955 avdd.n1124 avdd.n522 102.713
R956 avdd.n1230 avdd.n1224 102.713
R957 avdd.n1269 avdd.n1263 102.713
R958 avdd.n1308 avdd.n1302 102.713
R959 avdd.n815 avdd.n814 101.953
R960 avdd.n1083 avdd.n1082 101.953
R961 avdd.n528 avdd.n92 74.7265
R962 avdd.n351 avdd.n317 99.1365
R963 avdd.n392 avdd.n359 99.1365
R964 avdd.n1240 avdd.n1206 99.1365
R965 avdd.n1279 avdd.n1246 99.1365
R966 avdd.n1318 avdd.n1286 99.1365
R967 avdd.n1113 avdd.n1106 96.3205
R968 avdd.n179 avdd.n178 95.4885
R969 avdd.n457 avdd.n456 95.4885
R970 avdd.n199 avdd.t117 92.5005
R971 avdd.n200 avdd.n199 92.5005
R972 avdd.t37 avdd.n192 92.5005
R973 avdd.n192 avdd.n121 92.5005
R974 avdd.n190 avdd.t156 92.5005
R975 avdd.n190 avdd.n135 92.5005
R976 avdd.n184 avdd.n183 92.5005
R977 avdd.t141 avdd.n156 92.5005
R978 avdd.n156 avdd.n155 92.5005
R979 avdd.n163 avdd.t149 92.5005
R980 avdd.n164 avdd.n163 92.5005
R981 avdd.t178 avdd.n167 92.5005
R982 avdd.n167 avdd.n166 92.5005
R983 avdd.n177 avdd.n176 92.5005
R984 avdd.n173 avdd.t128 92.5005
R985 avdd.n173 avdd.n172 92.5005
R986 avdd.t178 avdd.n144 92.5005
R987 avdd.n144 avdd.n142 92.5005
R988 avdd.t149 avdd.n162 92.5005
R989 avdd.n162 avdd.n161 92.5005
R990 avdd.n159 avdd.n158 92.5005
R991 avdd.t1 avdd.n181 92.5005
R992 avdd.n181 avdd.n138 92.5005
R993 avdd.t156 avdd.n189 92.5005
R994 avdd.n189 avdd.n188 92.5005
R995 avdd.n193 avdd.t37 92.5005
R996 avdd.n194 avdd.n193 92.5005
R997 avdd.n197 avdd.n196 92.5005
R998 avdd.n312 avdd.t103 92.5005
R999 avdd.n313 avdd.n312 92.5005
R1000 avdd.t157 avdd.n305 92.5005
R1001 avdd.n305 avdd.n276 92.5005
R1002 avdd.n303 avdd.t58 92.5005
R1003 avdd.n303 avdd.n289 92.5005
R1004 avdd.n296 avdd.n295 92.5005
R1005 avdd.n298 avdd.t163 92.5005
R1006 avdd.n299 avdd.n298 92.5005
R1007 avdd.t58 avdd.n302 92.5005
R1008 avdd.n302 avdd.n301 92.5005
R1009 avdd.n306 avdd.t157 92.5005
R1010 avdd.n307 avdd.n306 92.5005
R1011 avdd.n310 avdd.n309 92.5005
R1012 avdd.n354 avdd.t121 92.5005
R1013 avdd.n355 avdd.n354 92.5005
R1014 avdd.t109 avdd.n347 92.5005
R1015 avdd.n347 avdd.n315 92.5005
R1016 avdd.n345 avdd.t177 92.5005
R1017 avdd.n345 avdd.n331 92.5005
R1018 avdd.n338 avdd.n337 92.5005
R1019 avdd.n340 avdd.t171 92.5005
R1020 avdd.n341 avdd.n340 92.5005
R1021 avdd.t177 avdd.n344 92.5005
R1022 avdd.n344 avdd.n343 92.5005
R1023 avdd.n348 avdd.t109 92.5005
R1024 avdd.n349 avdd.n348 92.5005
R1025 avdd.n352 avdd.n351 92.5005
R1026 avdd.n395 avdd.t73 92.5005
R1027 avdd.n396 avdd.n395 92.5005
R1028 avdd.t151 avdd.n388 92.5005
R1029 avdd.n388 avdd.n357 92.5005
R1030 avdd.n386 avdd.t0 92.5005
R1031 avdd.n386 avdd.n55 92.5005
R1032 avdd.n379 avdd.n378 92.5005
R1033 avdd.n381 avdd.t29 92.5005
R1034 avdd.n382 avdd.n381 92.5005
R1035 avdd.t0 avdd.n385 92.5005
R1036 avdd.n385 avdd.n384 92.5005
R1037 avdd.n389 avdd.t151 92.5005
R1038 avdd.n390 avdd.n389 92.5005
R1039 avdd.n393 avdd.n392 92.5005
R1040 avdd.n274 avdd.t97 92.5005
R1041 avdd.n275 avdd.n274 92.5005
R1042 avdd.t47 avdd.n267 92.5005
R1043 avdd.n267 avdd.n238 92.5005
R1044 avdd.n265 avdd.t165 92.5005
R1045 avdd.n265 avdd.n251 92.5005
R1046 avdd.n258 avdd.n257 92.5005
R1047 avdd.n260 avdd.t107 92.5005
R1048 avdd.n261 avdd.n260 92.5005
R1049 avdd.t165 avdd.n264 92.5005
R1050 avdd.n264 avdd.n263 92.5005
R1051 avdd.n268 avdd.t47 92.5005
R1052 avdd.n269 avdd.n268 92.5005
R1053 avdd.n272 avdd.n271 92.5005
R1054 avdd.n477 avdd.t115 92.5005
R1055 avdd.n478 avdd.n477 92.5005
R1056 avdd.t105 avdd.n470 92.5005
R1057 avdd.n470 avdd.n397 92.5005
R1058 avdd.n468 avdd.t127 92.5005
R1059 avdd.n468 avdd.n413 92.5005
R1060 avdd.n462 avdd.n461 92.5005
R1061 avdd.t143 avdd.n434 92.5005
R1062 avdd.n434 avdd.n433 92.5005
R1063 avdd.n441 avdd.t9 92.5005
R1064 avdd.n442 avdd.n441 92.5005
R1065 avdd.t164 avdd.n445 92.5005
R1066 avdd.n445 avdd.n444 92.5005
R1067 avdd.n455 avdd.n454 92.5005
R1068 avdd.n451 avdd.t6 92.5005
R1069 avdd.n451 avdd.n450 92.5005
R1070 avdd.t164 avdd.n422 92.5005
R1071 avdd.n422 avdd.n420 92.5005
R1072 avdd.t9 avdd.n440 92.5005
R1073 avdd.n440 avdd.n439 92.5005
R1074 avdd.n437 avdd.n436 92.5005
R1075 avdd.t31 avdd.n459 92.5005
R1076 avdd.n459 avdd.n416 92.5005
R1077 avdd.t127 avdd.n467 92.5005
R1078 avdd.n467 avdd.n466 92.5005
R1079 avdd.n471 avdd.t105 92.5005
R1080 avdd.n472 avdd.n471 92.5005
R1081 avdd.n475 avdd.n474 92.5005
R1082 avdd.n1202 avdd.t93 92.5005
R1083 avdd.n1203 avdd.n1202 92.5005
R1084 avdd.t136 avdd.n1195 92.5005
R1085 avdd.n1195 avdd.n480 92.5005
R1086 avdd.n1193 avdd.t36 92.5005
R1087 avdd.n1193 avdd.n60 92.5005
R1088 avdd.n1187 avdd.n1186 92.5005
R1089 avdd.n1182 avdd.t49 92.5005
R1090 avdd.n1182 avdd.n495 92.5005
R1091 avdd.t36 avdd.n1192 92.5005
R1092 avdd.n1192 avdd.n1191 92.5005
R1093 avdd.n1196 avdd.t136 92.5005
R1094 avdd.n1197 avdd.n1196 92.5005
R1095 avdd.n1200 avdd.n1199 92.5005
R1096 avdd.t15 avdd.n516 92.5005
R1097 avdd.n516 avdd.n515 92.5005
R1098 avdd.n1168 avdd.t139 92.5005
R1099 avdd.n1169 avdd.n1168 92.5005
R1100 avdd.t7 avdd.n501 92.5005
R1101 avdd.n1171 avdd.n501 92.5005
R1102 avdd.n1176 avdd.n497 92.5005
R1103 avdd.n1178 avdd.t179 92.5005
R1104 avdd.n1179 avdd.n1178 92.5005
R1105 avdd.n1163 avdd.t7 92.5005
R1106 avdd.n1164 avdd.n1163 92.5005
R1107 avdd.t139 avdd.n1167 92.5005
R1108 avdd.n1167 avdd.n1166 92.5005
R1109 avdd.n519 avdd.n518 92.5005
R1110 avdd.n1161 avdd.n1160 92.5005
R1111 avdd.n1162 avdd.n1161 92.5005
R1112 avdd.n1160 avdd.n1131 92.5005
R1113 avdd.n1131 avdd.n520 92.5005
R1114 avdd.n1160 avdd.n1130 92.5005
R1115 avdd.n1143 avdd.n1130 92.5005
R1116 avdd.n1160 avdd.n1159 92.5005
R1117 avdd.n1159 avdd.n1158 92.5005
R1118 avdd.n1153 avdd.n1140 92.5005
R1119 avdd.n1149 avdd.n1140 92.5005
R1120 avdd.n1153 avdd.n1152 92.5005
R1121 avdd.n1152 avdd.n1151 92.5005
R1122 avdd.n1154 avdd.n1153 92.5005
R1123 avdd.n1154 avdd.n1139 92.5005
R1124 avdd.n1153 avdd.n1137 92.5005
R1125 avdd.n1137 avdd.n1136 92.5005
R1126 avdd.n91 avdd.n1127 92.5005
R1127 avdd.t130 avdd.n1125 92.5005
R1128 avdd.n1125 avdd.n1124 92.5005
R1129 avdd.n1108 avdd.t181 92.5005
R1130 avdd.n1108 avdd.n1107 92.5005
R1131 avdd.n1117 avdd.t168 92.5005
R1132 avdd.n1118 avdd.n1117 92.5005
R1133 avdd.t167 avdd.n1120 92.5005
R1134 avdd.n1120 avdd.n1119 92.5005
R1135 avdd.n1121 avdd.t167 92.5005
R1136 avdd.n1122 avdd.n1121 92.5005
R1137 avdd.t168 avdd.n1116 92.5005
R1138 avdd.n1116 avdd.n1115 92.5005
R1139 avdd.n1113 avdd.n1112 92.5005
R1140 avdd.n1003 avdd.t77 92.5005
R1141 avdd.n1003 avdd.n1002 92.5005
R1142 avdd.n1016 avdd.t17 92.5005
R1143 avdd.n1017 avdd.n1016 92.5005
R1144 avdd.n994 avdd.t16 92.5005
R1145 avdd.n994 avdd.n547 92.5005
R1146 avdd.n543 avdd.n63 92.5005
R1147 avdd.t166 avdd.n542 92.5005
R1148 avdd.n542 avdd.n541 92.5005
R1149 avdd.n1011 avdd.t16 92.5005
R1150 avdd.n1012 avdd.n1011 92.5005
R1151 avdd.t17 avdd.n1015 92.5005
R1152 avdd.n1015 avdd.n1014 92.5005
R1153 avdd.n1007 avdd.n1006 92.5005
R1154 avdd.t125 avdd.n761 92.5005
R1155 avdd.n761 avdd.n760 92.5005
R1156 avdd.n828 avdd.t173 92.5005
R1157 avdd.n829 avdd.n828 92.5005
R1158 avdd.t172 avdd.n822 92.5005
R1159 avdd.n822 avdd.n821 92.5005
R1160 avdd.n819 avdd.n773 92.5005
R1161 avdd.n793 avdd.t147 92.5005
R1162 avdd.n793 avdd.n792 92.5005
R1163 avdd.n806 avdd.t23 92.5005
R1164 avdd.n807 avdd.n806 92.5005
R1165 avdd.n784 avdd.t22 92.5005
R1166 avdd.n784 avdd.n781 92.5005
R1167 avdd.n777 avdd.n66 92.5005
R1168 avdd.t63 avdd.n776 92.5005
R1169 avdd.n776 avdd.n775 92.5005
R1170 avdd.n801 avdd.t22 92.5005
R1171 avdd.n802 avdd.n801 92.5005
R1172 avdd.t23 avdd.n805 92.5005
R1173 avdd.n805 avdd.n804 92.5005
R1174 avdd.n797 avdd.n796 92.5005
R1175 avdd.t39 avdd.n817 92.5005
R1176 avdd.n817 avdd.n816 92.5005
R1177 avdd.n823 avdd.t172 92.5005
R1178 avdd.n824 avdd.n823 92.5005
R1179 avdd.t173 avdd.n827 92.5005
R1180 avdd.n827 avdd.n826 92.5005
R1181 avdd.n764 avdd.n763 92.5005
R1182 avdd.n841 avdd.t99 92.5005
R1183 avdd.n841 avdd.n840 92.5005
R1184 avdd.n869 avdd.t41 92.5005
R1185 avdd.n870 avdd.n869 92.5005
R1186 avdd.t40 avdd.n863 92.5005
R1187 avdd.n863 avdd.n862 92.5005
R1188 avdd.n860 avdd.t50 92.5005
R1189 avdd.n861 avdd.n860 92.5005
R1190 avdd.n858 avdd.n857 92.5005
R1191 avdd.n864 avdd.t40 92.5005
R1192 avdd.n865 avdd.n864 92.5005
R1193 avdd.t41 avdd.n868 92.5005
R1194 avdd.n868 avdd.n867 92.5005
R1195 avdd.n845 avdd.n844 92.5005
R1196 avdd.n720 avdd.t101 92.5005
R1197 avdd.n720 avdd.n719 92.5005
R1198 avdd.n748 avdd.t44 92.5005
R1199 avdd.n749 avdd.n748 92.5005
R1200 avdd.t43 avdd.n742 92.5005
R1201 avdd.n742 avdd.n741 92.5005
R1202 avdd.n739 avdd.t5 92.5005
R1203 avdd.n739 avdd.n734 92.5005
R1204 avdd.n737 avdd.n736 92.5005
R1205 avdd.n743 avdd.t43 92.5005
R1206 avdd.n744 avdd.n743 92.5005
R1207 avdd.t44 avdd.n747 92.5005
R1208 avdd.n747 avdd.n746 92.5005
R1209 avdd.n724 avdd.n723 92.5005
R1210 avdd.n881 avdd.t123 92.5005
R1211 avdd.n881 avdd.n880 92.5005
R1212 avdd.n909 avdd.t154 92.5005
R1213 avdd.n910 avdd.n909 92.5005
R1214 avdd.t153 avdd.n903 92.5005
R1215 avdd.n903 avdd.n902 92.5005
R1216 avdd.n900 avdd.t32 92.5005
R1217 avdd.n900 avdd.n895 92.5005
R1218 avdd.n898 avdd.n897 92.5005
R1219 avdd.n904 avdd.t153 92.5005
R1220 avdd.n905 avdd.n904 92.5005
R1221 avdd.t154 avdd.n908 92.5005
R1222 avdd.n908 avdd.n907 92.5005
R1223 avdd.n885 avdd.n884 92.5005
R1224 avdd.n922 avdd.t95 92.5005
R1225 avdd.n922 avdd.n921 92.5005
R1226 avdd.n950 avdd.t34 92.5005
R1227 avdd.n951 avdd.n950 92.5005
R1228 avdd.t33 avdd.n944 92.5005
R1229 avdd.n944 avdd.n943 92.5005
R1230 avdd.n941 avdd.t170 92.5005
R1231 avdd.n942 avdd.n941 92.5005
R1232 avdd.n939 avdd.n938 92.5005
R1233 avdd.n945 avdd.t33 92.5005
R1234 avdd.n946 avdd.n945 92.5005
R1235 avdd.t34 avdd.n949 92.5005
R1236 avdd.n949 avdd.n948 92.5005
R1237 avdd.n926 avdd.n925 92.5005
R1238 avdd.n962 avdd.t91 92.5005
R1239 avdd.n962 avdd.n961 92.5005
R1240 avdd.n990 avdd.t20 92.5005
R1241 avdd.n991 avdd.n990 92.5005
R1242 avdd.t19 avdd.n984 92.5005
R1243 avdd.n984 avdd.n983 92.5005
R1244 avdd.n981 avdd.t27 92.5005
R1245 avdd.n982 avdd.n981 92.5005
R1246 avdd.n979 avdd.n978 92.5005
R1247 avdd.n985 avdd.t19 92.5005
R1248 avdd.n986 avdd.n985 92.5005
R1249 avdd.t20 avdd.n989 92.5005
R1250 avdd.n989 avdd.n988 92.5005
R1251 avdd.n966 avdd.n965 92.5005
R1252 avdd.n598 avdd.t81 92.5005
R1253 avdd.n598 avdd.n597 92.5005
R1254 avdd.n626 avdd.t60 92.5005
R1255 avdd.n627 avdd.n626 92.5005
R1256 avdd.t59 avdd.n620 92.5005
R1257 avdd.n620 avdd.n619 92.5005
R1258 avdd.n617 avdd.t138 92.5005
R1259 avdd.n617 avdd.n612 92.5005
R1260 avdd.n615 avdd.n614 92.5005
R1261 avdd.n621 avdd.t59 92.5005
R1262 avdd.n622 avdd.n621 92.5005
R1263 avdd.t60 avdd.n625 92.5005
R1264 avdd.n625 avdd.n624 92.5005
R1265 avdd.n602 avdd.n601 92.5005
R1266 avdd.n639 avdd.t111 92.5005
R1267 avdd.n639 avdd.n638 92.5005
R1268 avdd.n667 avdd.t3 92.5005
R1269 avdd.n668 avdd.n667 92.5005
R1270 avdd.t2 avdd.n661 92.5005
R1271 avdd.n661 avdd.n660 92.5005
R1272 avdd.n658 avdd.t30 92.5005
R1273 avdd.n658 avdd.n653 92.5005
R1274 avdd.n656 avdd.n655 92.5005
R1275 avdd.n662 avdd.t2 92.5005
R1276 avdd.n663 avdd.n662 92.5005
R1277 avdd.t3 avdd.n666 92.5005
R1278 avdd.n666 avdd.n665 92.5005
R1279 avdd.n643 avdd.n642 92.5005
R1280 avdd.n680 avdd.t85 92.5005
R1281 avdd.n680 avdd.n679 92.5005
R1282 avdd.n708 avdd.t65 92.5005
R1283 avdd.n709 avdd.n708 92.5005
R1284 avdd.t64 avdd.n702 92.5005
R1285 avdd.n702 avdd.n701 92.5005
R1286 avdd.n699 avdd.t161 92.5005
R1287 avdd.n700 avdd.n699 92.5005
R1288 avdd.n697 avdd.n696 92.5005
R1289 avdd.n703 avdd.t64 92.5005
R1290 avdd.n704 avdd.n703 92.5005
R1291 avdd.t65 avdd.n707 92.5005
R1292 avdd.n707 avdd.n706 92.5005
R1293 avdd.n684 avdd.n683 92.5005
R1294 avdd.n558 avdd.t75 92.5005
R1295 avdd.n558 avdd.n557 92.5005
R1296 avdd.n586 avdd.t13 92.5005
R1297 avdd.n587 avdd.n586 92.5005
R1298 avdd.t12 avdd.n580 92.5005
R1299 avdd.n580 avdd.n579 92.5005
R1300 avdd.n577 avdd.t11 92.5005
R1301 avdd.n577 avdd.n572 92.5005
R1302 avdd.n575 avdd.n574 92.5005
R1303 avdd.n581 avdd.t12 92.5005
R1304 avdd.n582 avdd.n581 92.5005
R1305 avdd.t13 avdd.n585 92.5005
R1306 avdd.n585 avdd.n584 92.5005
R1307 avdd.n562 avdd.n561 92.5005
R1308 avdd.t119 avdd.n1029 92.5005
R1309 avdd.n1029 avdd.n1028 92.5005
R1310 avdd.n1096 avdd.t134 92.5005
R1311 avdd.n1097 avdd.n1096 92.5005
R1312 avdd.t133 avdd.n1090 92.5005
R1313 avdd.n1090 avdd.n1089 92.5005
R1314 avdd.n1087 avdd.n1041 92.5005
R1315 avdd.n1061 avdd.t145 92.5005
R1316 avdd.n1061 avdd.n1060 92.5005
R1317 avdd.n1074 avdd.t68 92.5005
R1318 avdd.n1075 avdd.n1074 92.5005
R1319 avdd.n1052 avdd.t67 92.5005
R1320 avdd.n1052 avdd.n1049 92.5005
R1321 avdd.n1045 avdd.n79 92.5005
R1322 avdd.t25 avdd.n1044 92.5005
R1323 avdd.n1044 avdd.n1043 92.5005
R1324 avdd.n1069 avdd.t67 92.5005
R1325 avdd.n1070 avdd.n1069 92.5005
R1326 avdd.t68 avdd.n1073 92.5005
R1327 avdd.n1073 avdd.n1072 92.5005
R1328 avdd.n1065 avdd.n1064 92.5005
R1329 avdd.t62 avdd.n1085 92.5005
R1330 avdd.n1085 avdd.n1084 92.5005
R1331 avdd.n1091 avdd.t133 92.5005
R1332 avdd.n1092 avdd.n1091 92.5005
R1333 avdd.t134 avdd.n1095 92.5005
R1334 avdd.n1095 avdd.n1094 92.5005
R1335 avdd.n1032 avdd.n1031 92.5005
R1336 avdd.n1243 avdd.t89 92.5005
R1337 avdd.n1244 avdd.n1243 92.5005
R1338 avdd.t53 avdd.n1236 92.5005
R1339 avdd.n1236 avdd.n1204 92.5005
R1340 avdd.n1234 avdd.t46 92.5005
R1341 avdd.n1234 avdd.n1220 92.5005
R1342 avdd.n1227 avdd.n1226 92.5005
R1343 avdd.n1229 avdd.t26 92.5005
R1344 avdd.n1230 avdd.n1229 92.5005
R1345 avdd.t46 avdd.n1233 92.5005
R1346 avdd.n1233 avdd.n1232 92.5005
R1347 avdd.n1237 avdd.t53 92.5005
R1348 avdd.n1238 avdd.n1237 92.5005
R1349 avdd.n1241 avdd.n1240 92.5005
R1350 avdd.n1282 avdd.t113 92.5005
R1351 avdd.n1283 avdd.n1282 92.5005
R1352 avdd.t175 avdd.n1275 92.5005
R1353 avdd.n1275 avdd.n1245 92.5005
R1354 avdd.n1273 avdd.t51 92.5005
R1355 avdd.n1273 avdd.n1259 92.5005
R1356 avdd.n1266 avdd.n1265 92.5005
R1357 avdd.n1268 avdd.t162 92.5005
R1358 avdd.n1269 avdd.n1268 92.5005
R1359 avdd.t51 avdd.n1272 92.5005
R1360 avdd.n1272 avdd.n1271 92.5005
R1361 avdd.n1276 avdd.t175 92.5005
R1362 avdd.n1277 avdd.n1276 92.5005
R1363 avdd.n1280 avdd.n1279 92.5005
R1364 avdd.n1321 avdd.t87 92.5005
R1365 avdd.n1322 avdd.n1321 92.5005
R1366 avdd.t70 avdd.n1314 92.5005
R1367 avdd.n1314 avdd.n1285 92.5005
R1368 avdd.n1312 avdd.t129 92.5005
R1369 avdd.n1312 avdd.n86 92.5005
R1370 avdd.n1305 avdd.n1304 92.5005
R1371 avdd.n1307 avdd.t108 92.5005
R1372 avdd.n1308 avdd.n1307 92.5005
R1373 avdd.t129 avdd.n1311 92.5005
R1374 avdd.n1311 avdd.n1310 92.5005
R1375 avdd.n1315 avdd.t70 92.5005
R1376 avdd.n1316 avdd.n1315 92.5005
R1377 avdd.n1319 avdd.n1318 92.5005
R1378 avdd.n236 avdd.t83 92.5005
R1379 avdd.n237 avdd.n236 92.5005
R1380 avdd.t131 avdd.n229 92.5005
R1381 avdd.n229 avdd.n201 92.5005
R1382 avdd.n227 avdd.t52 92.5005
R1383 avdd.n227 avdd.n213 92.5005
R1384 avdd.n220 avdd.n219 92.5005
R1385 avdd.n222 avdd.t28 92.5005
R1386 avdd.n223 avdd.n222 92.5005
R1387 avdd.t52 avdd.n226 92.5005
R1388 avdd.n226 avdd.n225 92.5005
R1389 avdd.n230 avdd.t131 92.5005
R1390 avdd.n231 avdd.n230 92.5005
R1391 avdd.n234 avdd.n233 92.5005
R1392 avdd.n1350 avdd.t79 92.5005
R1393 avdd.n1351 avdd.n1350 92.5005
R1394 avdd.t159 avdd.n1353 92.5005
R1395 avdd.n1353 avdd.n1352 92.5005
R1396 avdd.n1359 avdd.t72 92.5005
R1397 avdd.n1360 avdd.n1359 92.5005
R1398 avdd.n1335 avdd.n1334 92.5005
R1399 avdd.n1337 avdd.t55 92.5005
R1400 avdd.n1338 avdd.n1337 92.5005
R1401 avdd.t72 avdd.n1358 92.5005
R1402 avdd.n1358 avdd.n1357 92.5005
R1403 avdd.n1354 avdd.t159 92.5005
R1404 avdd.n1355 avdd.n1354 92.5005
R1405 avdd.n1348 avdd.n1347 92.5005
R1406 avdd.n1180 avdd.n496 82.9495
R1407 avdd.n1157 avdd.n1135 81.3181
R1408 avdd.n1148 avdd.n1147 81.3181
R1409 avdd.n171 avdd.n170 74.9181
R1410 avdd.n170 avdd.n11 74.9181
R1411 avdd.n152 avdd.n146 74.9181
R1412 avdd.n165 avdd.n146 74.9181
R1413 avdd.n187 avdd.n186 74.9181
R1414 avdd.n186 avdd.n49 74.9181
R1415 avdd.n133 avdd.n128 74.9181
R1416 avdd.n134 avdd.n133 74.9181
R1417 avdd.n300 avdd.n50 74.9181
R1418 avdd.n51 avdd.n50 74.9181
R1419 avdd.n287 avdd.n282 74.9181
R1420 avdd.n288 avdd.n287 74.9181
R1421 avdd.n342 avdd.n52 74.9181
R1422 avdd.n53 avdd.n52 74.9181
R1423 avdd.n329 avdd.n324 74.9181
R1424 avdd.n330 avdd.n329 74.9181
R1425 avdd.n383 avdd.n54 74.9181
R1426 avdd.n56 avdd.n54 74.9181
R1427 avdd.n371 avdd.n366 74.9181
R1428 avdd.n372 avdd.n371 74.9181
R1429 avdd.n262 avdd.n57 74.9181
R1430 avdd.n58 avdd.n57 74.9181
R1431 avdd.n249 avdd.n244 74.9181
R1432 avdd.n250 avdd.n249 74.9181
R1433 avdd.n449 avdd.n448 74.9181
R1434 avdd.n448 avdd.n19 74.9181
R1435 avdd.n430 avdd.n424 74.9181
R1436 avdd.n443 avdd.n424 74.9181
R1437 avdd.n465 avdd.n464 74.9181
R1438 avdd.n464 avdd.n59 74.9181
R1439 avdd.n411 avdd.n406 74.9181
R1440 avdd.n412 avdd.n411 74.9181
R1441 avdd.n1190 avdd.n1189 74.9181
R1442 avdd.n1189 avdd.n61 74.9181
R1443 avdd.n491 avdd.n486 74.9181
R1444 avdd.n492 avdd.n491 74.9181
R1445 avdd.n512 avdd.n503 74.9181
R1446 avdd.n8 avdd.n512 74.9181
R1447 avdd.n1170 avdd.n502 74.9181
R1448 avdd.n1165 avdd.n502 74.9181
R1449 avdd.n62 avdd.n1157 74.9181
R1450 avdd.n1147 avdd.n1144 74.9181
R1451 avdd.n535 avdd.n534 74.9181
R1452 avdd.n534 avdd.n529 74.9181
R1453 avdd.n1099 avdd.n64 74.9181
R1454 avdd.n1099 avdd.n546 74.9181
R1455 avdd.n1010 avdd.n992 74.9181
R1456 avdd.n1013 avdd.n1010 74.9181
R1457 avdd.n808 avdd.n67 74.9181
R1458 avdd.n808 avdd.n780 74.9181
R1459 avdd.n800 avdd.n782 74.9181
R1460 avdd.n803 avdd.n800 74.9181
R1461 avdd.n767 avdd.n750 74.9181
R1462 avdd.n825 avdd.n767 74.9181
R1463 avdd.n65 avdd.n772 74.9181
R1464 avdd.n772 avdd.n768 74.9181
R1465 avdd.n68 avdd.n854 74.9181
R1466 avdd.n854 avdd.n849 74.9181
R1467 avdd.n848 avdd.n831 74.9181
R1468 avdd.n866 avdd.n848 74.9181
R1469 avdd.n69 avdd.n733 74.9181
R1470 avdd.n733 avdd.n728 74.9181
R1471 avdd.n727 avdd.n710 74.9181
R1472 avdd.n745 avdd.n727 74.9181
R1473 avdd.n70 avdd.n894 74.9181
R1474 avdd.n894 avdd.n889 74.9181
R1475 avdd.n888 avdd.n871 74.9181
R1476 avdd.n906 avdd.n888 74.9181
R1477 avdd.n71 avdd.n935 74.9181
R1478 avdd.n935 avdd.n930 74.9181
R1479 avdd.n929 avdd.n912 74.9181
R1480 avdd.n947 avdd.n929 74.9181
R1481 avdd.n73 avdd.n975 74.9181
R1482 avdd.n975 avdd.n970 74.9181
R1483 avdd.n969 avdd.n952 74.9181
R1484 avdd.n987 avdd.n969 74.9181
R1485 avdd.n74 avdd.n611 74.9181
R1486 avdd.n611 avdd.n606 74.9181
R1487 avdd.n605 avdd.n588 74.9181
R1488 avdd.n623 avdd.n605 74.9181
R1489 avdd.n75 avdd.n652 74.9181
R1490 avdd.n652 avdd.n647 74.9181
R1491 avdd.n646 avdd.n629 74.9181
R1492 avdd.n664 avdd.n646 74.9181
R1493 avdd.n76 avdd.n693 74.9181
R1494 avdd.n693 avdd.n688 74.9181
R1495 avdd.n687 avdd.n670 74.9181
R1496 avdd.n705 avdd.n687 74.9181
R1497 avdd.n77 avdd.n571 74.9181
R1498 avdd.n571 avdd.n566 74.9181
R1499 avdd.n565 avdd.n548 74.9181
R1500 avdd.n583 avdd.n565 74.9181
R1501 avdd.n1076 avdd.n80 74.9181
R1502 avdd.n1076 avdd.n1048 74.9181
R1503 avdd.n1068 avdd.n1050 74.9181
R1504 avdd.n1071 avdd.n1068 74.9181
R1505 avdd.n1035 avdd.n1018 74.9181
R1506 avdd.n1093 avdd.n1035 74.9181
R1507 avdd.n78 avdd.n1040 74.9181
R1508 avdd.n1040 avdd.n1036 74.9181
R1509 avdd.n1231 avdd.n81 74.9181
R1510 avdd.n82 avdd.n81 74.9181
R1511 avdd.n1218 avdd.n1213 74.9181
R1512 avdd.n1219 avdd.n1218 74.9181
R1513 avdd.n1270 avdd.n83 74.9181
R1514 avdd.n84 avdd.n83 74.9181
R1515 avdd.n1257 avdd.n1252 74.9181
R1516 avdd.n1258 avdd.n1257 74.9181
R1517 avdd.n1309 avdd.n85 74.9181
R1518 avdd.n87 avdd.n85 74.9181
R1519 avdd.n1297 avdd.n1292 74.9181
R1520 avdd.n1298 avdd.n1297 74.9181
R1521 avdd.n224 avdd.n88 74.9181
R1522 avdd.n89 avdd.n88 74.9181
R1523 avdd.n211 avdd.n206 74.9181
R1524 avdd.n212 avdd.n211 74.9181
R1525 avdd.n1339 avdd.n1331 74.9181
R1526 avdd.n1331 avdd.n90 74.9181
R1527 avdd.n1356 avdd.n1341 74.9181
R1528 avdd.n1341 avdd.n1323 74.9181
R1529 avdd.n1123 avdd.n528 73.6933
R1530 avdd.n176 avdd.n175 69.4692
R1531 avdd.n158 avdd.n157 69.4692
R1532 avdd.n198 avdd.n197 69.4692
R1533 avdd.n183 avdd.n182 69.4692
R1534 avdd.n311 avdd.n310 69.4692
R1535 avdd.n297 avdd.n296 69.4692
R1536 avdd.n353 avdd.n352 69.4692
R1537 avdd.n339 avdd.n338 69.4692
R1538 avdd.n394 avdd.n393 69.4692
R1539 avdd.n380 avdd.n379 69.4692
R1540 avdd.n273 avdd.n272 69.4692
R1541 avdd.n259 avdd.n258 69.4692
R1542 avdd.n454 avdd.n453 69.4692
R1543 avdd.n436 avdd.n435 69.4692
R1544 avdd.n476 avdd.n475 69.4692
R1545 avdd.n461 avdd.n460 69.4692
R1546 avdd.n1186 avdd.n1185 69.4692
R1547 avdd.n1201 avdd.n1200 69.4692
R1548 avdd.n1177 avdd.n1176 69.4692
R1549 avdd.n518 avdd.n517 69.4692
R1550 avdd.n1127 avdd.n1126 69.4692
R1551 avdd.n1112 avdd.n1111 69.4692
R1552 avdd.n1102 avdd.n543 69.4692
R1553 avdd.n1006 avdd.n1005 69.4692
R1554 avdd.n819 avdd.n818 69.4692
R1555 avdd.n811 avdd.n777 69.4692
R1556 avdd.n796 avdd.n795 69.4692
R1557 avdd.n763 avdd.n762 69.4692
R1558 avdd.n844 avdd.n843 69.4692
R1559 avdd.n859 avdd.n858 69.4692
R1560 avdd.n723 avdd.n722 69.4692
R1561 avdd.n738 avdd.n737 69.4692
R1562 avdd.n884 avdd.n883 69.4692
R1563 avdd.n899 avdd.n898 69.4692
R1564 avdd.n925 avdd.n924 69.4692
R1565 avdd.n940 avdd.n939 69.4692
R1566 avdd.n965 avdd.n964 69.4692
R1567 avdd.n980 avdd.n979 69.4692
R1568 avdd.n601 avdd.n600 69.4692
R1569 avdd.n616 avdd.n615 69.4692
R1570 avdd.n642 avdd.n641 69.4692
R1571 avdd.n657 avdd.n656 69.4692
R1572 avdd.n683 avdd.n682 69.4692
R1573 avdd.n698 avdd.n697 69.4692
R1574 avdd.n561 avdd.n560 69.4692
R1575 avdd.n576 avdd.n575 69.4692
R1576 avdd.n1087 avdd.n1086 69.4692
R1577 avdd.n1079 avdd.n1045 69.4692
R1578 avdd.n1064 avdd.n1063 69.4692
R1579 avdd.n1031 avdd.n1030 69.4692
R1580 avdd.n1242 avdd.n1241 69.4692
R1581 avdd.n1228 avdd.n1227 69.4692
R1582 avdd.n1281 avdd.n1280 69.4692
R1583 avdd.n1267 avdd.n1266 69.4692
R1584 avdd.n1320 avdd.n1319 69.4692
R1585 avdd.n1306 avdd.n1305 69.4692
R1586 avdd.n235 avdd.n234 69.4692
R1587 avdd.n221 avdd.n220 69.4692
R1588 avdd.n1349 avdd.n1348 69.4692
R1589 avdd.n1336 avdd.n1335 69.4692
R1590 avdd.n179 avdd.n138 68.5324
R1591 avdd.n457 avdd.n416 68.5324
R1592 avdd.n816 avdd.n815 68.5324
R1593 avdd.n1084 avdd.n1083 68.5324
R1594 avdd.n1150 avdd.n521 66.6358
R1595 avdd.n172 avdd.n139 66.1539
R1596 avdd.n299 avdd.n293 66.1539
R1597 avdd.n261 avdd.n255 66.1539
R1598 avdd.n450 avdd.n417 66.1539
R1599 avdd.n1183 avdd.n495 66.1539
R1600 avdd.n1136 avdd.n1134 66.1539
R1601 avdd.n1104 avdd.n541 66.1539
R1602 avdd.n813 avdd.n775 66.1539
R1603 avdd.n857 avdd.n855 66.1539
R1604 avdd.n736 avdd.n735 66.1539
R1605 avdd.n897 avdd.n896 66.1539
R1606 avdd.n938 avdd.n936 66.1539
R1607 avdd.n978 avdd.n976 66.1539
R1608 avdd.n614 avdd.n613 66.1539
R1609 avdd.n655 avdd.n654 66.1539
R1610 avdd.n696 avdd.n694 66.1539
R1611 avdd.n574 avdd.n573 66.1539
R1612 avdd.n1081 avdd.n1043 66.1539
R1613 avdd.n223 avdd.n217 66.1539
R1614 avdd.n1338 avdd.n1332 66.1539
R1615 avdd.n159 avdd.t142 65.7774
R1616 avdd.n309 avdd.n96 65.7774
R1617 avdd.n271 avdd.n98 65.7774
R1618 avdd.n437 avdd.n99 65.7774
R1619 avdd.n1199 avdd.n101 65.7774
R1620 avdd.n1149 avdd.n104 65.7774
R1621 avdd.n1007 avdd.n105 65.7774
R1622 avdd.n797 avdd.n106 65.7774
R1623 avdd.n764 avdd.n107 65.7774
R1624 avdd.n845 avdd.n108 65.7774
R1625 avdd.n724 avdd.n109 65.7774
R1626 avdd.n885 avdd.n110 65.7774
R1627 avdd.n926 avdd.n111 65.7774
R1628 avdd.n966 avdd.n112 65.7774
R1629 avdd.n602 avdd.n113 65.7774
R1630 avdd.n643 avdd.n114 65.7774
R1631 avdd.n684 avdd.n115 65.7774
R1632 avdd.n562 avdd.n116 65.7774
R1633 avdd.n1065 avdd.n117 65.7774
R1634 avdd.n1032 avdd.n118 65.7774
R1635 avdd.n233 avdd.t84 65.7774
R1636 avdd.n1347 avdd.t80 65.7774
R1637 avdd.n196 avdd.n122 62.5774
R1638 avdd.n474 avdd.n399 62.5774
R1639 avdd.n160 avdd.t150 60.2358
R1640 avdd.n195 avdd.t38 60.2358
R1641 avdd.n308 avdd.n277 60.2358
R1642 avdd.n350 avdd.n316 60.2358
R1643 avdd.n391 avdd.n358 60.2358
R1644 avdd.n270 avdd.n239 60.2358
R1645 avdd.n438 avdd.n18 60.2358
R1646 avdd.n473 avdd.n398 60.2358
R1647 avdd.n1198 avdd.n481 60.2358
R1648 avdd.n1173 avdd.n1172 60.2358
R1649 avdd.n1114 avdd.n540 60.2358
R1650 avdd.n1008 avdd.n1001 60.2358
R1651 avdd.n798 avdd.n791 60.2358
R1652 avdd.n765 avdd.n758 60.2358
R1653 avdd.n846 avdd.n839 60.2358
R1654 avdd.n725 avdd.n718 60.2358
R1655 avdd.n886 avdd.n879 60.2358
R1656 avdd.n927 avdd.n920 60.2358
R1657 avdd.n967 avdd.n960 60.2358
R1658 avdd.n603 avdd.n596 60.2358
R1659 avdd.n644 avdd.n637 60.2358
R1660 avdd.n685 avdd.n678 60.2358
R1661 avdd.n563 avdd.n556 60.2358
R1662 avdd.n1066 avdd.n1059 60.2358
R1663 avdd.n1033 avdd.n1026 60.2358
R1664 avdd.n1239 avdd.n1205 60.2358
R1665 avdd.n1278 avdd.t176 60.2358
R1666 avdd.n1317 avdd.t71 60.2358
R1667 avdd.n232 avdd.t132 60.2358
R1668 avdd.t160 avdd.n1342 60.2358
R1669 avdd.n1123 avdd.n1122 59.5946
R1670 avdd.n160 avdd.n159 59.4829
R1671 avdd.n161 avdd.n160 59.4829
R1672 avdd.n161 avdd.n152 59.4829
R1673 avdd.n152 avdd.n142 59.4829
R1674 avdd.n171 avdd.n142 59.4829
R1675 avdd.n172 avdd.n171 59.4829
R1676 avdd.n196 avdd.n195 59.4829
R1677 avdd.n195 avdd.n194 59.4829
R1678 avdd.n194 avdd.n128 59.4829
R1679 avdd.n188 avdd.n128 59.4829
R1680 avdd.n188 avdd.n187 59.4829
R1681 avdd.n187 avdd.n138 59.4829
R1682 avdd.n309 avdd.n308 59.4829
R1683 avdd.n308 avdd.n307 59.4829
R1684 avdd.n307 avdd.n282 59.4829
R1685 avdd.n301 avdd.n282 59.4829
R1686 avdd.n301 avdd.n300 59.4829
R1687 avdd.n300 avdd.n299 59.4829
R1688 avdd.n351 avdd.n350 59.4829
R1689 avdd.n350 avdd.n349 59.4829
R1690 avdd.n349 avdd.n324 59.4829
R1691 avdd.n343 avdd.n324 59.4829
R1692 avdd.n343 avdd.n342 59.4829
R1693 avdd.n342 avdd.n341 59.4829
R1694 avdd.n392 avdd.n391 59.4829
R1695 avdd.n391 avdd.n390 59.4829
R1696 avdd.n390 avdd.n366 59.4829
R1697 avdd.n384 avdd.n366 59.4829
R1698 avdd.n384 avdd.n383 59.4829
R1699 avdd.n383 avdd.n382 59.4829
R1700 avdd.n271 avdd.n270 59.4829
R1701 avdd.n270 avdd.n269 59.4829
R1702 avdd.n269 avdd.n244 59.4829
R1703 avdd.n263 avdd.n244 59.4829
R1704 avdd.n263 avdd.n262 59.4829
R1705 avdd.n262 avdd.n261 59.4829
R1706 avdd.n438 avdd.n437 59.4829
R1707 avdd.n439 avdd.n438 59.4829
R1708 avdd.n439 avdd.n430 59.4829
R1709 avdd.n430 avdd.n420 59.4829
R1710 avdd.n449 avdd.n420 59.4829
R1711 avdd.n450 avdd.n449 59.4829
R1712 avdd.n474 avdd.n473 59.4829
R1713 avdd.n473 avdd.n472 59.4829
R1714 avdd.n472 avdd.n406 59.4829
R1715 avdd.n466 avdd.n406 59.4829
R1716 avdd.n466 avdd.n465 59.4829
R1717 avdd.n465 avdd.n416 59.4829
R1718 avdd.n1199 avdd.n1198 59.4829
R1719 avdd.n1198 avdd.n1197 59.4829
R1720 avdd.n1197 avdd.n486 59.4829
R1721 avdd.n1191 avdd.n486 59.4829
R1722 avdd.n1191 avdd.n1190 59.4829
R1723 avdd.n1190 avdd.n495 59.4829
R1724 avdd.n1172 avdd.n497 59.4829
R1725 avdd.n1172 avdd.n1171 59.4829
R1726 avdd.n1171 avdd.n1170 59.4829
R1727 avdd.n1170 avdd.n1169 59.4829
R1728 avdd.n1169 avdd.n503 59.4829
R1729 avdd.n515 avdd.n503 59.4829
R1730 avdd.n1122 avdd.n529 59.4829
R1731 avdd.n1115 avdd.n529 59.4829
R1732 avdd.n1115 avdd.n1114 59.4829
R1733 avdd.n1114 avdd.n1113 59.4829
R1734 avdd.n546 avdd.n541 59.4829
R1735 avdd.n1012 avdd.n546 59.4829
R1736 avdd.n1013 avdd.n1012 59.4829
R1737 avdd.n1014 avdd.n1013 59.4829
R1738 avdd.n1014 avdd.n1008 59.4829
R1739 avdd.n1008 avdd.n1007 59.4829
R1740 avdd.n780 avdd.n775 59.4829
R1741 avdd.n802 avdd.n780 59.4829
R1742 avdd.n803 avdd.n802 59.4829
R1743 avdd.n804 avdd.n803 59.4829
R1744 avdd.n804 avdd.n798 59.4829
R1745 avdd.n798 avdd.n797 59.4829
R1746 avdd.n816 avdd.n768 59.4829
R1747 avdd.n824 avdd.n768 59.4829
R1748 avdd.n825 avdd.n824 59.4829
R1749 avdd.n826 avdd.n825 59.4829
R1750 avdd.n826 avdd.n765 59.4829
R1751 avdd.n765 avdd.n764 59.4829
R1752 avdd.n857 avdd.n849 59.4829
R1753 avdd.n865 avdd.n849 59.4829
R1754 avdd.n866 avdd.n865 59.4829
R1755 avdd.n867 avdd.n866 59.4829
R1756 avdd.n867 avdd.n846 59.4829
R1757 avdd.n846 avdd.n845 59.4829
R1758 avdd.n736 avdd.n728 59.4829
R1759 avdd.n744 avdd.n728 59.4829
R1760 avdd.n745 avdd.n744 59.4829
R1761 avdd.n746 avdd.n745 59.4829
R1762 avdd.n746 avdd.n725 59.4829
R1763 avdd.n725 avdd.n724 59.4829
R1764 avdd.n897 avdd.n889 59.4829
R1765 avdd.n905 avdd.n889 59.4829
R1766 avdd.n906 avdd.n905 59.4829
R1767 avdd.n907 avdd.n906 59.4829
R1768 avdd.n907 avdd.n886 59.4829
R1769 avdd.n886 avdd.n885 59.4829
R1770 avdd.n938 avdd.n930 59.4829
R1771 avdd.n946 avdd.n930 59.4829
R1772 avdd.n947 avdd.n946 59.4829
R1773 avdd.n948 avdd.n947 59.4829
R1774 avdd.n948 avdd.n927 59.4829
R1775 avdd.n927 avdd.n926 59.4829
R1776 avdd.n978 avdd.n970 59.4829
R1777 avdd.n986 avdd.n970 59.4829
R1778 avdd.n987 avdd.n986 59.4829
R1779 avdd.n988 avdd.n987 59.4829
R1780 avdd.n988 avdd.n967 59.4829
R1781 avdd.n967 avdd.n966 59.4829
R1782 avdd.n614 avdd.n606 59.4829
R1783 avdd.n622 avdd.n606 59.4829
R1784 avdd.n623 avdd.n622 59.4829
R1785 avdd.n624 avdd.n623 59.4829
R1786 avdd.n624 avdd.n603 59.4829
R1787 avdd.n603 avdd.n602 59.4829
R1788 avdd.n655 avdd.n647 59.4829
R1789 avdd.n663 avdd.n647 59.4829
R1790 avdd.n664 avdd.n663 59.4829
R1791 avdd.n665 avdd.n664 59.4829
R1792 avdd.n665 avdd.n644 59.4829
R1793 avdd.n644 avdd.n643 59.4829
R1794 avdd.n696 avdd.n688 59.4829
R1795 avdd.n704 avdd.n688 59.4829
R1796 avdd.n705 avdd.n704 59.4829
R1797 avdd.n706 avdd.n705 59.4829
R1798 avdd.n706 avdd.n685 59.4829
R1799 avdd.n685 avdd.n684 59.4829
R1800 avdd.n574 avdd.n566 59.4829
R1801 avdd.n582 avdd.n566 59.4829
R1802 avdd.n583 avdd.n582 59.4829
R1803 avdd.n584 avdd.n583 59.4829
R1804 avdd.n584 avdd.n563 59.4829
R1805 avdd.n563 avdd.n562 59.4829
R1806 avdd.n1048 avdd.n1043 59.4829
R1807 avdd.n1070 avdd.n1048 59.4829
R1808 avdd.n1071 avdd.n1070 59.4829
R1809 avdd.n1072 avdd.n1071 59.4829
R1810 avdd.n1072 avdd.n1066 59.4829
R1811 avdd.n1066 avdd.n1065 59.4829
R1812 avdd.n1084 avdd.n1036 59.4829
R1813 avdd.n1092 avdd.n1036 59.4829
R1814 avdd.n1093 avdd.n1092 59.4829
R1815 avdd.n1094 avdd.n1093 59.4829
R1816 avdd.n1094 avdd.n1033 59.4829
R1817 avdd.n1033 avdd.n1032 59.4829
R1818 avdd.n1240 avdd.n1239 59.4829
R1819 avdd.n1239 avdd.n1238 59.4829
R1820 avdd.n1238 avdd.n1213 59.4829
R1821 avdd.n1232 avdd.n1213 59.4829
R1822 avdd.n1232 avdd.n1231 59.4829
R1823 avdd.n1231 avdd.n1230 59.4829
R1824 avdd.n1279 avdd.n1278 59.4829
R1825 avdd.n1278 avdd.n1277 59.4829
R1826 avdd.n1277 avdd.n1252 59.4829
R1827 avdd.n1271 avdd.n1252 59.4829
R1828 avdd.n1271 avdd.n1270 59.4829
R1829 avdd.n1270 avdd.n1269 59.4829
R1830 avdd.n1318 avdd.n1317 59.4829
R1831 avdd.n1317 avdd.n1316 59.4829
R1832 avdd.n1316 avdd.n1292 59.4829
R1833 avdd.n1310 avdd.n1292 59.4829
R1834 avdd.n1310 avdd.n1309 59.4829
R1835 avdd.n1309 avdd.n1308 59.4829
R1836 avdd.n233 avdd.n232 59.4829
R1837 avdd.n232 avdd.n231 59.4829
R1838 avdd.n231 avdd.n206 59.4829
R1839 avdd.n225 avdd.n206 59.4829
R1840 avdd.n225 avdd.n224 59.4829
R1841 avdd.n224 avdd.n223 59.4829
R1842 avdd.n1347 avdd.n1342 59.4829
R1843 avdd.n1355 avdd.n1342 59.4829
R1844 avdd.n1356 avdd.n1355 59.4829
R1845 avdd.n1357 avdd.n1356 59.4829
R1846 avdd.n1357 avdd.n1339 59.4829
R1847 avdd.n1339 avdd.n1338 59.4829
R1848 avdd.n1124 avdd.n1123 59.2674
R1849 avdd.n12 avdd.t150 58.7299
R1850 avdd.n10 avdd.t38 58.7299
R1851 avdd.n13 avdd.n277 58.7299
R1852 avdd.n14 avdd.n316 58.7299
R1853 avdd.n15 avdd.n358 58.7299
R1854 avdd.n16 avdd.n239 58.7299
R1855 avdd.n20 avdd.n18 58.7299
R1856 avdd.n17 avdd.n398 58.7299
R1857 avdd.n21 avdd.n481 58.7299
R1858 avdd.n1173 avdd.n22 58.7299
R1859 avdd.n23 avdd.n521 58.7299
R1860 avdd.n1001 avdd.n25 58.7299
R1861 avdd.n791 avdd.n27 58.7299
R1862 avdd.n758 avdd.n26 58.7299
R1863 avdd.n839 avdd.n28 58.7299
R1864 avdd.n718 avdd.n29 58.7299
R1865 avdd.n879 avdd.n30 58.7299
R1866 avdd.n920 avdd.n31 58.7299
R1867 avdd.n960 avdd.n32 58.7299
R1868 avdd.n596 avdd.n33 58.7299
R1869 avdd.n637 avdd.n34 58.7299
R1870 avdd.n678 avdd.n35 58.7299
R1871 avdd.n556 avdd.n36 58.7299
R1872 avdd.n1059 avdd.n38 58.7299
R1873 avdd.n1026 avdd.n37 58.7299
R1874 avdd.n540 avdd.n24 58.7299
R1875 avdd.n39 avdd.n1205 58.7299
R1876 avdd.n40 avdd.t176 58.7299
R1877 avdd.n41 avdd.t71 58.7299
R1878 avdd.n42 avdd.t132 58.7299
R1879 avdd.n44 avdd.t160 58.7299
R1880 avdd.n1150 avdd.n1149 53.0829
R1881 avdd.n1136 avdd.n1135 53.0829
R1882 avdd.n1148 avdd.n1139 53.0829
R1883 avdd.n1139 avdd.n1135 53.0829
R1884 avdd.n1151 avdd.n1150 53.0829
R1885 avdd.n1151 avdd.n1148 53.0829
R1886 avdd.n180 avdd.n179 51.4345
R1887 avdd.n458 avdd.n457 51.4345
R1888 avdd.n815 avdd.n774 51.4345
R1889 avdd.n1083 avdd.n1042 51.4345
R1890 avdd.n169 avdd.n168 46.2505
R1891 avdd.n170 avdd.n169 46.2505
R1892 avdd.n153 avdd.n148 46.2505
R1893 avdd.t150 avdd.n153 46.2505
R1894 avdd.n154 avdd.t142 46.2505
R1895 avdd.n174 avdd.n139 46.2505
R1896 avdd.n149 avdd.n143 46.2505
R1897 avdd.n149 avdd.n146 46.2505
R1898 avdd.n124 avdd.t118 46.2505
R1899 avdd.n185 avdd.n136 46.2505
R1900 avdd.n186 avdd.n185 46.2505
R1901 avdd.n126 avdd.n125 46.2505
R1902 avdd.n126 avdd.t38 46.2505
R1903 avdd.n131 avdd.n130 46.2505
R1904 avdd.n133 avdd.n131 46.2505
R1905 avdd.n294 avdd.n293 46.2505
R1906 avdd.n280 avdd.n279 46.2505
R1907 avdd.n280 avdd.n277 46.2505
R1908 avdd.n96 avdd.n95 46.2505
R1909 avdd.n292 avdd.n290 46.2505
R1910 avdd.n50 avdd.n292 46.2505
R1911 avdd.n285 avdd.n284 46.2505
R1912 avdd.n287 avdd.n285 46.2505
R1913 avdd.n336 avdd.n335 46.2505
R1914 avdd.n320 avdd.n319 46.2505
R1915 avdd.n322 avdd.n321 46.2505
R1916 avdd.n322 avdd.n316 46.2505
R1917 avdd.n334 avdd.n332 46.2505
R1918 avdd.n52 avdd.n334 46.2505
R1919 avdd.n327 avdd.n326 46.2505
R1920 avdd.n329 avdd.n327 46.2505
R1921 avdd.n377 avdd.n376 46.2505
R1922 avdd.n362 avdd.n361 46.2505
R1923 avdd.n364 avdd.n363 46.2505
R1924 avdd.n364 avdd.n358 46.2505
R1925 avdd.n375 avdd.n373 46.2505
R1926 avdd.n54 avdd.n375 46.2505
R1927 avdd.n369 avdd.n368 46.2505
R1928 avdd.n371 avdd.n369 46.2505
R1929 avdd.n256 avdd.n255 46.2505
R1930 avdd.n242 avdd.n241 46.2505
R1931 avdd.n242 avdd.n239 46.2505
R1932 avdd.n98 avdd.n97 46.2505
R1933 avdd.n254 avdd.n252 46.2505
R1934 avdd.n57 avdd.n254 46.2505
R1935 avdd.n247 avdd.n246 46.2505
R1936 avdd.n249 avdd.n247 46.2505
R1937 avdd.n447 avdd.n446 46.2505
R1938 avdd.n448 avdd.n447 46.2505
R1939 avdd.n431 avdd.n426 46.2505
R1940 avdd.n18 avdd.n431 46.2505
R1941 avdd.n432 avdd.n99 46.2505
R1942 avdd.n452 avdd.n417 46.2505
R1943 avdd.n427 avdd.n421 46.2505
R1944 avdd.n427 avdd.n424 46.2505
R1945 avdd.n402 avdd.n401 46.2505
R1946 avdd.n463 avdd.n414 46.2505
R1947 avdd.n464 avdd.n463 46.2505
R1948 avdd.n404 avdd.n403 46.2505
R1949 avdd.n404 avdd.n398 46.2505
R1950 avdd.n409 avdd.n408 46.2505
R1951 avdd.n411 avdd.n409 46.2505
R1952 avdd.n1188 avdd.n493 46.2505
R1953 avdd.n1189 avdd.n1188 46.2505
R1954 avdd.n484 avdd.n483 46.2505
R1955 avdd.n484 avdd.n481 46.2505
R1956 avdd.n101 avdd.n100 46.2505
R1957 avdd.n1184 avdd.n1183 46.2505
R1958 avdd.n489 avdd.n488 46.2505
R1959 avdd.n491 avdd.n489 46.2505
R1960 avdd.n1174 avdd.n500 46.2505
R1961 avdd.n1174 avdd.n1173 46.2505
R1962 avdd.n499 avdd.n496 46.2505
R1963 avdd.n514 avdd.n513 46.2505
R1964 avdd.n511 avdd.n506 46.2505
R1965 avdd.n512 avdd.n511 46.2505
R1966 avdd.n509 avdd.n507 46.2505
R1967 avdd.n509 avdd.n502 46.2505
R1968 avdd.t56 avdd.n102 46.2505
R1969 avdd.n104 avdd.n102 46.2505
R1970 avdd.n1141 avdd.t56 46.2505
R1971 avdd.n1141 avdd.n521 46.2505
R1972 avdd.n1146 avdd.t56 46.2505
R1973 avdd.n1147 avdd.n1146 46.2505
R1974 avdd.n1156 avdd.t56 46.2505
R1975 avdd.n1157 avdd.n1156 46.2505
R1976 avdd.n1132 avdd.t56 46.2505
R1977 avdd.n1134 avdd.n1132 46.2505
R1978 avdd.n524 avdd.n522 46.2505
R1979 avdd.n527 avdd.n525 46.2505
R1980 avdd.n528 avdd.n527 46.2505
R1981 avdd.n533 avdd.n531 46.2505
R1982 avdd.n534 avdd.n533 46.2505
R1983 avdd.n539 avdd.n537 46.2505
R1984 avdd.n540 avdd.n539 46.2505
R1985 avdd.n1110 avdd.n1109 46.2505
R1986 avdd.n1104 avdd.n1103 46.2505
R1987 avdd.n1101 avdd.n1100 46.2505
R1988 avdd.n1100 avdd.n1099 46.2505
R1989 avdd.n1000 avdd.n996 46.2505
R1990 avdd.n1001 avdd.n1000 46.2505
R1991 avdd.n1004 avdd.n105 46.2505
R1992 avdd.n1009 avdd.n997 46.2505
R1993 avdd.n1010 avdd.n1009 46.2505
R1994 avdd.n813 avdd.n812 46.2505
R1995 avdd.n810 avdd.n809 46.2505
R1996 avdd.n809 avdd.n808 46.2505
R1997 avdd.n790 avdd.n786 46.2505
R1998 avdd.n791 avdd.n790 46.2505
R1999 avdd.n794 avdd.n106 46.2505
R2000 avdd.n799 avdd.n787 46.2505
R2001 avdd.n800 avdd.n799 46.2505
R2002 avdd.n771 avdd.n770 46.2505
R2003 avdd.n772 avdd.n771 46.2505
R2004 avdd.n759 avdd.n107 46.2505
R2005 avdd.n757 avdd.n753 46.2505
R2006 avdd.n758 avdd.n757 46.2505
R2007 avdd.n766 avdd.n754 46.2505
R2008 avdd.n767 avdd.n766 46.2505
R2009 avdd.n853 avdd.n851 46.2505
R2010 avdd.n854 avdd.n853 46.2505
R2011 avdd.n838 avdd.n834 46.2505
R2012 avdd.n839 avdd.n838 46.2505
R2013 avdd.n856 avdd.n855 46.2505
R2014 avdd.n842 avdd.n108 46.2505
R2015 avdd.n847 avdd.n835 46.2505
R2016 avdd.n848 avdd.n847 46.2505
R2017 avdd.n731 avdd.n730 46.2505
R2018 avdd.n733 avdd.n731 46.2505
R2019 avdd.n717 avdd.n713 46.2505
R2020 avdd.n718 avdd.n717 46.2505
R2021 avdd.n735 avdd.n732 46.2505
R2022 avdd.n721 avdd.n109 46.2505
R2023 avdd.n726 avdd.n714 46.2505
R2024 avdd.n727 avdd.n726 46.2505
R2025 avdd.n892 avdd.n891 46.2505
R2026 avdd.n894 avdd.n892 46.2505
R2027 avdd.n878 avdd.n874 46.2505
R2028 avdd.n879 avdd.n878 46.2505
R2029 avdd.n896 avdd.n893 46.2505
R2030 avdd.n882 avdd.n110 46.2505
R2031 avdd.n887 avdd.n875 46.2505
R2032 avdd.n888 avdd.n887 46.2505
R2033 avdd.n934 avdd.n932 46.2505
R2034 avdd.n935 avdd.n934 46.2505
R2035 avdd.n919 avdd.n915 46.2505
R2036 avdd.n920 avdd.n919 46.2505
R2037 avdd.n937 avdd.n936 46.2505
R2038 avdd.n923 avdd.n111 46.2505
R2039 avdd.n928 avdd.n916 46.2505
R2040 avdd.n929 avdd.n928 46.2505
R2041 avdd.n974 avdd.n972 46.2505
R2042 avdd.n975 avdd.n974 46.2505
R2043 avdd.n959 avdd.n955 46.2505
R2044 avdd.n960 avdd.n959 46.2505
R2045 avdd.n977 avdd.n976 46.2505
R2046 avdd.n963 avdd.n112 46.2505
R2047 avdd.n968 avdd.n956 46.2505
R2048 avdd.n969 avdd.n968 46.2505
R2049 avdd.n609 avdd.n608 46.2505
R2050 avdd.n611 avdd.n609 46.2505
R2051 avdd.n595 avdd.n591 46.2505
R2052 avdd.n596 avdd.n595 46.2505
R2053 avdd.n613 avdd.n610 46.2505
R2054 avdd.n599 avdd.n113 46.2505
R2055 avdd.n604 avdd.n592 46.2505
R2056 avdd.n605 avdd.n604 46.2505
R2057 avdd.n650 avdd.n649 46.2505
R2058 avdd.n652 avdd.n650 46.2505
R2059 avdd.n636 avdd.n632 46.2505
R2060 avdd.n637 avdd.n636 46.2505
R2061 avdd.n654 avdd.n651 46.2505
R2062 avdd.n640 avdd.n114 46.2505
R2063 avdd.n645 avdd.n633 46.2505
R2064 avdd.n646 avdd.n645 46.2505
R2065 avdd.n692 avdd.n690 46.2505
R2066 avdd.n693 avdd.n692 46.2505
R2067 avdd.n677 avdd.n673 46.2505
R2068 avdd.n678 avdd.n677 46.2505
R2069 avdd.n695 avdd.n694 46.2505
R2070 avdd.n681 avdd.n115 46.2505
R2071 avdd.n686 avdd.n674 46.2505
R2072 avdd.n687 avdd.n686 46.2505
R2073 avdd.n569 avdd.n568 46.2505
R2074 avdd.n571 avdd.n569 46.2505
R2075 avdd.n555 avdd.n551 46.2505
R2076 avdd.n556 avdd.n555 46.2505
R2077 avdd.n573 avdd.n570 46.2505
R2078 avdd.n559 avdd.n116 46.2505
R2079 avdd.n564 avdd.n552 46.2505
R2080 avdd.n565 avdd.n564 46.2505
R2081 avdd.n1081 avdd.n1080 46.2505
R2082 avdd.n1078 avdd.n1077 46.2505
R2083 avdd.n1077 avdd.n1076 46.2505
R2084 avdd.n1058 avdd.n1054 46.2505
R2085 avdd.n1059 avdd.n1058 46.2505
R2086 avdd.n1062 avdd.n117 46.2505
R2087 avdd.n1067 avdd.n1055 46.2505
R2088 avdd.n1068 avdd.n1067 46.2505
R2089 avdd.n1039 avdd.n1038 46.2505
R2090 avdd.n1040 avdd.n1039 46.2505
R2091 avdd.n1027 avdd.n118 46.2505
R2092 avdd.n1025 avdd.n1021 46.2505
R2093 avdd.n1026 avdd.n1025 46.2505
R2094 avdd.n1034 avdd.n1022 46.2505
R2095 avdd.n1035 avdd.n1034 46.2505
R2096 avdd.n1225 avdd.n1224 46.2505
R2097 avdd.n1209 avdd.n1208 46.2505
R2098 avdd.n1211 avdd.n1210 46.2505
R2099 avdd.n1211 avdd.n1205 46.2505
R2100 avdd.n1223 avdd.n1221 46.2505
R2101 avdd.n81 avdd.n1223 46.2505
R2102 avdd.n1216 avdd.n1215 46.2505
R2103 avdd.n1218 avdd.n1216 46.2505
R2104 avdd.n1264 avdd.n1263 46.2505
R2105 avdd.n1248 avdd.t114 46.2505
R2106 avdd.n1250 avdd.n1249 46.2505
R2107 avdd.n1250 avdd.t176 46.2505
R2108 avdd.n1262 avdd.n1260 46.2505
R2109 avdd.n83 avdd.n1262 46.2505
R2110 avdd.n1255 avdd.n1254 46.2505
R2111 avdd.n1257 avdd.n1255 46.2505
R2112 avdd.n1303 avdd.n1302 46.2505
R2113 avdd.n1288 avdd.t88 46.2505
R2114 avdd.n1290 avdd.n1289 46.2505
R2115 avdd.n1290 avdd.t71 46.2505
R2116 avdd.n1301 avdd.n1299 46.2505
R2117 avdd.n85 avdd.n1301 46.2505
R2118 avdd.n1295 avdd.n1294 46.2505
R2119 avdd.n1297 avdd.n1295 46.2505
R2120 avdd.n218 avdd.n217 46.2505
R2121 avdd.n204 avdd.n203 46.2505
R2122 avdd.n204 avdd.t132 46.2505
R2123 avdd.t84 avdd.n119 46.2505
R2124 avdd.n216 avdd.n214 46.2505
R2125 avdd.n88 avdd.n216 46.2505
R2126 avdd.n209 avdd.n208 46.2505
R2127 avdd.n211 avdd.n209 46.2505
R2128 avdd.n1333 avdd.n1332 46.2505
R2129 avdd.n1346 avdd.n1344 46.2505
R2130 avdd.t160 avdd.n1346 46.2505
R2131 avdd.t80 avdd.n120 46.2505
R2132 avdd.n1330 avdd.n1326 46.2505
R2133 avdd.n1331 avdd.n1330 46.2505
R2134 avdd.n1340 avdd.n1327 46.2505
R2135 avdd.n1341 avdd.n1340 46.2505
R2136 avdd.n1158 avdd.n1134 28.0084
R2137 avdd.n861 avdd.n855 28.0084
R2138 avdd.n735 avdd.n734 28.0084
R2139 avdd.n896 avdd.n895 28.0084
R2140 avdd.n942 avdd.n936 28.0084
R2141 avdd.n982 avdd.n976 28.0084
R2142 avdd.n613 avdd.n612 28.0084
R2143 avdd.n654 avdd.n653 28.0084
R2144 avdd.n700 avdd.n694 28.0084
R2145 avdd.n573 avdd.n572 28.0084
R2146 avdd.n295 avdd.n293 27.8811
R2147 avdd.n337 avdd.n335 27.8811
R2148 avdd.n378 avdd.n376 27.8811
R2149 avdd.n257 avdd.n255 27.8811
R2150 avdd.n519 avdd.n513 27.8811
R2151 avdd.n1226 avdd.n1224 27.8811
R2152 avdd.n1265 avdd.n1263 27.8811
R2153 avdd.n1304 avdd.n1302 27.8811
R2154 avdd.n219 avdd.n217 27.8811
R2155 avdd.n1334 avdd.n1332 27.8811
R2156 avdd.n1351 avdd.t80 27.8177
R2157 avdd.n237 avdd.t84 27.8177
R2158 avdd.n1028 avdd.n118 27.8177
R2159 avdd.n1060 avdd.n117 27.8177
R2160 avdd.n557 avdd.n116 27.8177
R2161 avdd.n679 avdd.n115 27.8177
R2162 avdd.n638 avdd.n114 27.8177
R2163 avdd.n597 avdd.n113 27.8177
R2164 avdd.n961 avdd.n112 27.8177
R2165 avdd.n921 avdd.n111 27.8177
R2166 avdd.n880 avdd.n110 27.8177
R2167 avdd.n719 avdd.n109 27.8177
R2168 avdd.n840 avdd.n108 27.8177
R2169 avdd.n760 avdd.n107 27.8177
R2170 avdd.n792 avdd.n106 27.8177
R2171 avdd.n1002 avdd.n105 27.8177
R2172 avdd.n1203 avdd.n101 27.8177
R2173 avdd.n433 avdd.n99 27.8177
R2174 avdd.n275 avdd.n98 27.8177
R2175 avdd.n313 avdd.n96 27.8177
R2176 avdd.n155 avdd.t142 27.8177
R2177 avdd.n184 avdd.n179 27.3691
R2178 avdd.n462 avdd.n457 27.3691
R2179 avdd.n815 avdd.n773 27.3691
R2180 avdd.n1083 avdd.n1041 27.3691
R2181 avdd.n200 avdd.n122 24.4897
R2182 avdd.n355 avdd.n317 24.4897
R2183 avdd.n396 avdd.n359 24.4897
R2184 avdd.n478 avdd.n399 24.4897
R2185 avdd.n1244 avdd.n1206 24.4897
R2186 avdd.n1283 avdd.n1246 24.4897
R2187 avdd.n1322 avdd.n1286 24.4897
R2188 avdd.n1107 avdd.n1106 21.0337
R2189 avdd.n1105 avdd.n1104 19.2005
R2190 avdd.n814 avdd.n813 19.2005
R2191 avdd.n1082 avdd.n1081 19.2005
R2192 avdd.n182 avdd.t1 17.933
R2193 avdd.n157 avdd.t141 17.933
R2194 avdd.n175 avdd.t128 17.933
R2195 avdd.t117 avdd.n198 17.933
R2196 avdd.t163 avdd.n297 17.933
R2197 avdd.t103 avdd.n311 17.933
R2198 avdd.t171 avdd.n339 17.933
R2199 avdd.t121 avdd.n353 17.933
R2200 avdd.t29 avdd.n380 17.933
R2201 avdd.t73 avdd.n394 17.933
R2202 avdd.t107 avdd.n259 17.933
R2203 avdd.t97 avdd.n273 17.933
R2204 avdd.n460 avdd.t31 17.933
R2205 avdd.n435 avdd.t143 17.933
R2206 avdd.n453 avdd.t6 17.933
R2207 avdd.t115 avdd.n476 17.933
R2208 avdd.t93 avdd.n1201 17.933
R2209 avdd.n1185 avdd.t49 17.933
R2210 avdd.n517 avdd.t15 17.933
R2211 avdd.t179 avdd.n1177 17.933
R2212 avdd.n1102 avdd.t166 17.933
R2213 avdd.n1005 avdd.t77 17.933
R2214 avdd.n811 avdd.t63 17.933
R2215 avdd.n795 avdd.t147 17.933
R2216 avdd.n762 avdd.t125 17.933
R2217 avdd.n818 avdd.t39 17.933
R2218 avdd.t50 avdd.n859 17.933
R2219 avdd.n843 avdd.t99 17.933
R2220 avdd.t5 avdd.n738 17.933
R2221 avdd.n722 avdd.t101 17.933
R2222 avdd.t32 avdd.n899 17.933
R2223 avdd.n883 avdd.t123 17.933
R2224 avdd.t170 avdd.n940 17.933
R2225 avdd.n924 avdd.t95 17.933
R2226 avdd.t27 avdd.n980 17.933
R2227 avdd.n964 avdd.t91 17.933
R2228 avdd.t138 avdd.n616 17.933
R2229 avdd.n600 avdd.t81 17.933
R2230 avdd.t30 avdd.n657 17.933
R2231 avdd.n641 avdd.t111 17.933
R2232 avdd.t161 avdd.n698 17.933
R2233 avdd.n682 avdd.t85 17.933
R2234 avdd.t11 avdd.n576 17.933
R2235 avdd.n560 avdd.t75 17.933
R2236 avdd.n1079 avdd.t25 17.933
R2237 avdd.n1063 avdd.t145 17.933
R2238 avdd.n1030 avdd.t119 17.933
R2239 avdd.n1086 avdd.t62 17.933
R2240 avdd.n1126 avdd.t130 17.933
R2241 avdd.n1111 avdd.t181 17.933
R2242 avdd.t26 avdd.n1228 17.933
R2243 avdd.t89 avdd.n1242 17.933
R2244 avdd.t162 avdd.n1267 17.933
R2245 avdd.t113 avdd.n1281 17.933
R2246 avdd.t108 avdd.n1306 17.933
R2247 avdd.t87 avdd.n1320 17.933
R2248 avdd.t28 avdd.n221 17.933
R2249 avdd.t83 avdd.n235 17.933
R2250 avdd.t55 avdd.n1336 17.933
R2251 avdd.t79 avdd.n1349 17.933
R2252 avdd.n1162 avdd.n103 15.3036
R2253 avdd.n178 avdd.n177 15.1451
R2254 avdd.n456 avdd.n455 15.1451
R2255 avdd.n1187 avdd.n1181 15.1451
R2256 avdd.n1128 avdd.n91 13.5368
R2257 avdd.n178 avdd.n139 12.7365
R2258 avdd.n456 avdd.n417 12.7365
R2259 avdd.n1183 avdd.n1181 12.7365
R2260 avdd.n1128 avdd.n522 12.7365
R2261 avdd.n104 avdd.n103 12.5047
R2262 avdd.n72 avdd.n1 10.2828
R2263 avdd.n7 avdd.n94 10.2739
R2264 avdd.t118 avdd.n122 10.0397
R2265 avdd.n319 avdd.n317 10.0397
R2266 avdd.n361 avdd.n359 10.0397
R2267 avdd.n401 avdd.n399 10.0397
R2268 avdd.n1208 avdd.n1206 10.0397
R2269 avdd.t114 avdd.n1246 10.0397
R2270 avdd.t88 avdd.n1286 10.0397
R2271 avdd.n10 avdd.n200 10.0124
R2272 avdd.n134 avdd.n121 10.0124
R2273 avdd.n135 avdd.n134 10.0124
R2274 avdd.n49 avdd.n184 10.0124
R2275 avdd.n155 avdd.n12 10.0124
R2276 avdd.n165 avdd.n164 10.0124
R2277 avdd.n166 avdd.n165 10.0124
R2278 avdd.n177 avdd.n11 10.0124
R2279 avdd.n13 avdd.n313 10.0124
R2280 avdd.n288 avdd.n276 10.0124
R2281 avdd.n289 avdd.n288 10.0124
R2282 avdd.n295 avdd.n51 10.0124
R2283 avdd.n14 avdd.n355 10.0124
R2284 avdd.n330 avdd.n315 10.0124
R2285 avdd.n331 avdd.n330 10.0124
R2286 avdd.n337 avdd.n53 10.0124
R2287 avdd.n15 avdd.n396 10.0124
R2288 avdd.n372 avdd.n357 10.0124
R2289 avdd.n55 avdd.n372 10.0124
R2290 avdd.n378 avdd.n56 10.0124
R2291 avdd.n16 avdd.n275 10.0124
R2292 avdd.n250 avdd.n238 10.0124
R2293 avdd.n251 avdd.n250 10.0124
R2294 avdd.n257 avdd.n58 10.0124
R2295 avdd.n17 avdd.n478 10.0124
R2296 avdd.n412 avdd.n397 10.0124
R2297 avdd.n413 avdd.n412 10.0124
R2298 avdd.n59 avdd.n462 10.0124
R2299 avdd.n433 avdd.n20 10.0124
R2300 avdd.n443 avdd.n442 10.0124
R2301 avdd.n444 avdd.n443 10.0124
R2302 avdd.n455 avdd.n19 10.0124
R2303 avdd.n21 avdd.n1203 10.0124
R2304 avdd.n492 avdd.n480 10.0124
R2305 avdd.n60 avdd.n492 10.0124
R2306 avdd.n61 avdd.n1187 10.0124
R2307 avdd.n1179 avdd.n22 10.0124
R2308 avdd.n1165 avdd.n1164 10.0124
R2309 avdd.n1166 avdd.n1165 10.0124
R2310 avdd.n8 avdd.n519 10.0124
R2311 avdd.n23 avdd.n1162 10.0124
R2312 avdd.n1144 avdd.n520 10.0124
R2313 avdd.n1144 avdd.n1143 10.0124
R2314 avdd.n1158 avdd.n62 10.0124
R2315 avdd.n1119 avdd.n535 10.0124
R2316 avdd.n1118 avdd.n535 10.0124
R2317 avdd.n1107 avdd.n24 10.0124
R2318 avdd.n64 avdd.n63 10.0124
R2319 avdd.n992 avdd.n547 10.0124
R2320 avdd.n1017 avdd.n992 10.0124
R2321 avdd.n1002 avdd.n25 10.0124
R2322 avdd.n773 avdd.n65 10.0124
R2323 avdd.n821 avdd.n750 10.0124
R2324 avdd.n829 avdd.n750 10.0124
R2325 avdd.n760 avdd.n26 10.0124
R2326 avdd.n67 avdd.n66 10.0124
R2327 avdd.n782 avdd.n781 10.0124
R2328 avdd.n807 avdd.n782 10.0124
R2329 avdd.n792 avdd.n27 10.0124
R2330 avdd.n68 avdd.n861 10.0124
R2331 avdd.n862 avdd.n831 10.0124
R2332 avdd.n870 avdd.n831 10.0124
R2333 avdd.n840 avdd.n28 10.0124
R2334 avdd.n734 avdd.n69 10.0124
R2335 avdd.n741 avdd.n710 10.0124
R2336 avdd.n749 avdd.n710 10.0124
R2337 avdd.n719 avdd.n29 10.0124
R2338 avdd.n895 avdd.n70 10.0124
R2339 avdd.n902 avdd.n871 10.0124
R2340 avdd.n910 avdd.n871 10.0124
R2341 avdd.n880 avdd.n30 10.0124
R2342 avdd.n71 avdd.n942 10.0124
R2343 avdd.n943 avdd.n912 10.0124
R2344 avdd.n951 avdd.n912 10.0124
R2345 avdd.n921 avdd.n31 10.0124
R2346 avdd.n73 avdd.n982 10.0124
R2347 avdd.n983 avdd.n952 10.0124
R2348 avdd.n991 avdd.n952 10.0124
R2349 avdd.n961 avdd.n32 10.0124
R2350 avdd.n612 avdd.n74 10.0124
R2351 avdd.n619 avdd.n588 10.0124
R2352 avdd.n627 avdd.n588 10.0124
R2353 avdd.n597 avdd.n33 10.0124
R2354 avdd.n653 avdd.n75 10.0124
R2355 avdd.n660 avdd.n629 10.0124
R2356 avdd.n668 avdd.n629 10.0124
R2357 avdd.n638 avdd.n34 10.0124
R2358 avdd.n76 avdd.n700 10.0124
R2359 avdd.n701 avdd.n670 10.0124
R2360 avdd.n709 avdd.n670 10.0124
R2361 avdd.n679 avdd.n35 10.0124
R2362 avdd.n572 avdd.n77 10.0124
R2363 avdd.n579 avdd.n548 10.0124
R2364 avdd.n587 avdd.n548 10.0124
R2365 avdd.n557 avdd.n36 10.0124
R2366 avdd.n1041 avdd.n78 10.0124
R2367 avdd.n1089 avdd.n1018 10.0124
R2368 avdd.n1097 avdd.n1018 10.0124
R2369 avdd.n1028 avdd.n37 10.0124
R2370 avdd.n80 avdd.n79 10.0124
R2371 avdd.n1050 avdd.n1049 10.0124
R2372 avdd.n1075 avdd.n1050 10.0124
R2373 avdd.n1060 avdd.n38 10.0124
R2374 avdd.n39 avdd.n1244 10.0124
R2375 avdd.n1219 avdd.n1204 10.0124
R2376 avdd.n1220 avdd.n1219 10.0124
R2377 avdd.n1226 avdd.n82 10.0124
R2378 avdd.n40 avdd.n1283 10.0124
R2379 avdd.n1258 avdd.n1245 10.0124
R2380 avdd.n1259 avdd.n1258 10.0124
R2381 avdd.n1265 avdd.n84 10.0124
R2382 avdd.n41 avdd.n1322 10.0124
R2383 avdd.n1298 avdd.n1285 10.0124
R2384 avdd.n86 avdd.n1298 10.0124
R2385 avdd.n1304 avdd.n87 10.0124
R2386 avdd.n42 avdd.n237 10.0124
R2387 avdd.n212 avdd.n201 10.0124
R2388 avdd.n213 avdd.n212 10.0124
R2389 avdd.n219 avdd.n89 10.0124
R2390 avdd.n44 avdd.n1351 10.0124
R2391 avdd.n1352 avdd.n1323 10.0124
R2392 avdd.n1360 avdd.n1323 10.0124
R2393 avdd.n1334 avdd.n90 10.0124
R2394 avdd.n135 avdd.n49 9.63218
R2395 avdd.n166 avdd.n11 9.63218
R2396 avdd.n289 avdd.n51 9.63218
R2397 avdd.n331 avdd.n53 9.63218
R2398 avdd.n56 avdd.n55 9.63218
R2399 avdd.n251 avdd.n58 9.63218
R2400 avdd.n413 avdd.n59 9.63218
R2401 avdd.n444 avdd.n19 9.63218
R2402 avdd.n61 avdd.n60 9.63218
R2403 avdd.n1166 avdd.n8 9.63218
R2404 avdd.n1143 avdd.n62 9.63218
R2405 avdd.n64 avdd.n547 9.63218
R2406 avdd.n821 avdd.n65 9.63218
R2407 avdd.n67 avdd.n781 9.63218
R2408 avdd.n862 avdd.n68 9.63218
R2409 avdd.n741 avdd.n69 9.63218
R2410 avdd.n902 avdd.n70 9.63218
R2411 avdd.n943 avdd.n71 9.63218
R2412 avdd.n983 avdd.n73 9.63218
R2413 avdd.n619 avdd.n74 9.63218
R2414 avdd.n660 avdd.n75 9.63218
R2415 avdd.n701 avdd.n76 9.63218
R2416 avdd.n579 avdd.n77 9.63218
R2417 avdd.n1089 avdd.n78 9.63218
R2418 avdd.n80 avdd.n1049 9.63218
R2419 avdd.n1220 avdd.n82 9.63218
R2420 avdd.n1259 avdd.n84 9.63218
R2421 avdd.n87 avdd.n86 9.63218
R2422 avdd.n213 avdd.n89 9.63218
R2423 avdd.n90 avdd.n1360 9.63218
R2424 avdd.n10 avdd.n121 9.44208
R2425 avdd.n164 avdd.n12 9.44208
R2426 avdd.n13 avdd.n276 9.44208
R2427 avdd.n14 avdd.n315 9.44208
R2428 avdd.n15 avdd.n357 9.44208
R2429 avdd.n16 avdd.n238 9.44208
R2430 avdd.n17 avdd.n397 9.44208
R2431 avdd.n442 avdd.n20 9.44208
R2432 avdd.n21 avdd.n480 9.44208
R2433 avdd.n1164 avdd.n22 9.44208
R2434 avdd.n23 avdd.n520 9.44208
R2435 avdd.n24 avdd.n1118 9.44208
R2436 avdd.n25 avdd.n1017 9.44208
R2437 avdd.n26 avdd.n829 9.44208
R2438 avdd.n27 avdd.n807 9.44208
R2439 avdd.n28 avdd.n870 9.44208
R2440 avdd.n29 avdd.n749 9.44208
R2441 avdd.n30 avdd.n910 9.44208
R2442 avdd.n31 avdd.n951 9.44208
R2443 avdd.n32 avdd.n991 9.44208
R2444 avdd.n33 avdd.n627 9.44208
R2445 avdd.n34 avdd.n668 9.44208
R2446 avdd.n35 avdd.n709 9.44208
R2447 avdd.n36 avdd.n587 9.44208
R2448 avdd.n37 avdd.n1097 9.44208
R2449 avdd.n38 avdd.n1075 9.44208
R2450 avdd.n39 avdd.n1204 9.44208
R2451 avdd.n40 avdd.n1245 9.44208
R2452 avdd.n41 avdd.n1285 9.44208
R2453 avdd.n42 avdd.n201 9.44208
R2454 avdd.n1352 avdd.n44 9.44208
R2455 avdd.n1119 avdd.n93 9.25199
R2456 avdd.n1105 avdd.n63 8.80842
R2457 avdd.n814 avdd.n66 8.80842
R2458 avdd.n1082 avdd.n79 8.80842
R2459 avdd.n1109 avdd.n1106 5.1205
R2460 avdd.n94 avdd.n6 1.85393
R2461 avdd.n3 avdd.n72 1.85393
R2462 avdd.n43 avdd.n46 1.44756
R2463 avdd.n45 avdd.n48 1.44756
R2464 avdd.n4 avdd.n314 1.38738
R2465 avdd.n0 avdd.n628 1.38738
R2466 avdd.n46 avdd.n7 1.29301
R2467 avdd.n5 avdd.n4 1.29301
R2468 avdd.n1 avdd.n45 1.29301
R2469 avdd.n2 avdd.n0 1.29301
R2470 avdd.n48 avdd.n830 1.27579
R2471 avdd.n43 avdd.n47 1.27579
R2472 avdd.n92 avdd.n91 8.92781
R2473 avdd.n80 avdd.n38 3.40329
R2474 avdd.n67 avdd.n27 3.40329
R2475 avdd.n20 avdd.n19 3.40329
R2476 avdd.n12 avdd.n11 3.40329
R2477 avdd.n93 avdd.n24 3.02309
R2478 avdd.n7 avdd.n1284 2.26079
R2479 avdd.n6 avdd.n479 2.26079
R2480 avdd.n4 avdd.n356 2.26079
R2481 avdd.n3 avdd.n1098 2.26079
R2482 avdd.n1 avdd.n911 2.26079
R2483 avdd.n0 avdd.n669 2.26079
R2484 avdd.n46 avdd.n42 2.13726
R2485 avdd.n45 avdd.n29 2.13726
R2486 avdd.n9 avdd.n8 2.06153
R2487 avdd.n44 avdd.n43 1.98976
R2488 avdd.n48 avdd.n28 1.98976
R2489 avdd.n22 avdd.n9 1.98976
R2490 avdd.n46 avdd.n89 1.79966
R2491 avdd.n1284 avdd.n84 1.79966
R2492 avdd.n1098 avdd.n78 1.79966
R2493 avdd.n2 avdd.n77 1.79966
R2494 avdd.n669 avdd.n75 1.79966
R2495 avdd.n628 avdd.n74 1.79966
R2496 avdd.n911 avdd.n70 1.79966
R2497 avdd.n45 avdd.n69 1.79966
R2498 avdd.n830 avdd.n65 1.79966
R2499 avdd.n9 avdd.n62 1.79966
R2500 avdd.n479 avdd.n59 1.79966
R2501 avdd.n5 avdd.n58 1.79966
R2502 avdd.n356 avdd.n53 1.79966
R2503 avdd.n314 avdd.n51 1.79966
R2504 avdd.n47 avdd.n49 1.79966
R2505 avdd.n94 avdd.n82 1.75543
R2506 avdd.n73 avdd.n72 1.75476
R2507 avdd.n72 avdd.n32 1.67806
R2508 avdd.n94 avdd.n39 1.67738
R2509 avdd.n7 avdd.n41 1.60413
R2510 avdd.n1284 avdd.n40 1.60413
R2511 avdd.n1098 avdd.n37 1.60413
R2512 avdd.n2 avdd.n36 1.60413
R2513 avdd.n0 avdd.n35 1.60413
R2514 avdd.n669 avdd.n34 1.60413
R2515 avdd.n628 avdd.n33 1.60413
R2516 avdd.n1 avdd.n31 1.60413
R2517 avdd.n911 avdd.n30 1.60413
R2518 avdd.n830 avdd.n26 1.60413
R2519 avdd.n3 avdd.n25 1.60413
R2520 avdd.n9 avdd.n23 1.60413
R2521 avdd.n6 avdd.n21 1.60413
R2522 avdd.n479 avdd.n17 1.60413
R2523 avdd.n5 avdd.n16 1.60413
R2524 avdd.n4 avdd.n15 1.60413
R2525 avdd.n356 avdd.n14 1.60413
R2526 avdd.n314 avdd.n13 1.60413
R2527 avdd.n47 avdd.n10 1.60413
R2528 avdd.n43 avdd.n90 1.41403
R2529 avdd.n87 avdd.n7 1.41403
R2530 avdd.n76 avdd.n0 1.41403
R2531 avdd.n71 avdd.n1 1.41403
R2532 avdd.n68 avdd.n48 1.41403
R2533 avdd.n64 avdd.n3 1.41403
R2534 avdd.n61 avdd.n6 1.41403
R2535 avdd.n56 avdd.n4 1.41403
R2536 avdd.n3 avdd.n2 1.38131
R2537 avdd.n6 avdd.n5 1.38131
R2538 avdd avdd.n0 0.0005
R2539 avss.n1116 avss.n385 1.5466e+06
R2540 avss.n1346 avss.n161 1.5466e+06
R2541 avss.n911 avss.n910 1.07653e+06
R2542 avss.n747 avss.n746 689333
R2543 avss.n437 avss.n434 481800
R2544 avss.n747 avss.n707 450478
R2545 avss.n1049 avss.n385 379647
R2546 avss.n1346 avss.n160 379647
R2547 avss.n745 avss.n744 253144
R2548 avss.n1234 avss.n282 253144
R2549 avss.n910 avss.n909 253144
R2550 avss.n1347 avss.n1346 253000
R2551 avss.n746 avss.n745 253000
R2552 avss.n1120 avss.n385 253000
R2553 avss.n435 avss.n434 55733.3
R2554 avss.n911 avss.n611 55733.3
R2555 avss.n1115 avss.n1114 42199.4
R2556 avss.n829 avss.n591 42199.4
R2557 avss.n1347 avss.n1 31533.3
R2558 avss.n1120 avss.n1119 31533.3
R2559 avss.n412 avss.n207 21280.2
R2560 avss.n210 avss.t140 20143.5
R2561 avss.n1268 avss.n212 18231
R2562 avss.n932 avss.n931 18202.6
R2563 avss.n933 avss.n932 17551.2
R2564 avss.n1300 avss.n212 17551.2
R2565 avss.n1304 avss.n1303 14667.6
R2566 avss.n934 avss.n933 13884.2
R2567 avss.n1300 avss.n1299 13884.2
R2568 avss.n1303 avss.n207 13514.3
R2569 avss.n933 avss.n342 10717.1
R2570 avss.n387 avss.n220 9354.62
R2571 avss.n956 avss.n955 9336.13
R2572 avss.n747 avss.n2 7225.92
R2573 avss.n932 avss.n611 5069.3
R2574 avss.n435 avss.n212 5069.3
R2575 avss.n1262 avss.n1261 4994.18
R2576 avss.n773 avss.n651 4979.11
R2577 avss.t140 avss.n198 4443.85
R2578 avss.n955 avss.n591 4285.35
R2579 avss.n1115 avss.n387 4266.87
R2580 avss.n1212 avss.n1211 3502.84
R2581 avss.n1264 avss.n1263 3389.65
R2582 avss.n1268 avss.n1267 3380.09
R2583 avss.n1266 avss.n1265 3377.51
R2584 avss.n808 avss.n774 3370.59
R2585 avss.n931 avss.n849 3361.15
R2586 avss.n848 avss.n809 3358.57
R2587 avss.n1263 avss.n1262 3338.79
R2588 avss.n1265 avss.n1264 3338.79
R2589 avss.n1267 avss.n1266 3329.4
R2590 avss.n774 avss.n773 3320.06
R2591 avss.n809 avss.n808 3320.06
R2592 avss.n849 avss.n848 3310.77
R2593 avss.n1304 avss.n206 3025.91
R2594 avss.n510 avss.n206 3025.91
R2595 avss.n1211 avss.n1210 2694.46
R2596 avss.n412 avss.n211 2660.95
R2597 avss.n1302 avss.n211 2550.29
R2598 avss.n611 avss.n592 2404.51
R2599 avss.n436 avss.n435 2404.51
R2600 avss.n979 avss.n567 2060.03
R2601 avss.n1396 avss.n110 2016.35
R2602 avss.n1397 avss.n110 2016.35
R2603 avss.n751 avss.n672 2016.35
R2604 avss.n750 avss.n672 2016.35
R2605 avss.n757 avss.n670 2016.35
R2606 avss.n756 avss.n670 2016.35
R2607 avss.n771 avss.n653 2016.35
R2608 avss.n771 avss.n652 2016.35
R2609 avss.n706 avss.n674 2016.35
R2610 avss.n706 avss.n673 2016.35
R2611 avss.n689 avss.n688 2016.35
R2612 avss.n690 avss.n688 2016.35
R2613 avss.n1335 avss.n173 2016.35
R2614 avss.n1336 avss.n173 2016.35
R2615 avss.n1342 avss.n163 2016.35
R2616 avss.n1342 avss.n162 2016.35
R2617 avss.n976 avss.n569 2016.35
R2618 avss.n976 avss.n568 2016.35
R2619 avss.n962 avss.n589 2016.35
R2620 avss.n961 avss.n589 2016.35
R2621 avss.n937 avss.n610 2016.35
R2622 avss.n936 avss.n610 2016.35
R2623 avss.n953 avss.n594 2016.35
R2624 avss.n953 avss.n593 2016.35
R2625 avss.n1033 avss.n556 2016.35
R2626 avss.n1032 avss.n556 2016.35
R2627 avss.n1018 avss.n565 2016.35
R2628 avss.n1017 avss.n565 2016.35
R2629 avss.n1169 avss.n1167 2016.35
R2630 avss.n1170 avss.n1167 2016.35
R2631 avss.n1187 avss.n366 2016.35
R2632 avss.n1186 avss.n366 2016.35
R2633 avss.n306 avss.n304 2016.35
R2634 avss.n307 avss.n304 2016.35
R2635 avss.n322 avss.n288 2016.35
R2636 avss.n321 avss.n288 2016.35
R2637 avss.n1260 avss.n270 2016.35
R2638 avss.n1260 avss.n269 2016.35
R2639 avss.n1237 avss.n281 2016.35
R2640 avss.n1238 avss.n281 2016.35
R2641 avss.n478 avss.n428 2016.35
R2642 avss.n477 avss.n428 2016.35
R2643 avss.n492 avss.n409 2016.35
R2644 avss.n491 avss.n409 2016.35
R2645 avss.n1293 avss.n61 2016.35
R2646 avss.n1292 avss.n61 2016.35
R2647 avss.n1298 avss.n214 2016.35
R2648 avss.n1298 avss.n213 2016.35
R2649 avss.n1078 avss.n1077 2016.35
R2650 avss.n1078 avss.n392 2016.35
R2651 avss.n537 avss.n406 2016.35
R2652 avss.n538 avss.n406 2016.35
R2653 avss.n1271 avss.n262 2016.35
R2654 avss.n1272 avss.n262 2016.35
R2655 avss.n1287 avss.n245 2016.35
R2656 avss.n1286 avss.n245 2016.35
R2657 avss.n455 avss.n453 2016.35
R2658 avss.n456 avss.n453 2016.35
R2659 avss.n471 avss.n432 2016.35
R2660 avss.n470 avss.n432 2016.35
R2661 avss.n1098 avss.n62 2016.35
R2662 avss.n1097 avss.n62 2016.35
R2663 avss.n1113 avss.n389 2016.35
R2664 avss.n1113 avss.n388 2016.35
R2665 avss.n1063 avss.n63 2016.35
R2666 avss.n1062 avss.n63 2016.35
R2667 avss.n1051 avss.n1048 2016.35
R2668 avss.n1052 avss.n1048 2016.35
R2669 avss.n1147 avss.n65 2016.35
R2670 avss.n1146 avss.n65 2016.35
R2671 avss.n1153 avss.n384 2016.35
R2672 avss.n1153 avss.n383 2016.35
R2673 avss.n1159 avss.n59 2016.35
R2674 avss.n1158 avss.n59 2016.35
R2675 avss.n1007 avss.n981 2016.35
R2676 avss.n1007 avss.n980 2016.35
R2677 avss.n1194 avss.n363 2016.35
R2678 avss.n1193 avss.n363 2016.35
R2679 avss.n1209 avss.n344 2016.35
R2680 avss.n1209 avss.n343 2016.35
R2681 avss.n1232 avss.n286 2016.35
R2682 avss.n1232 avss.n285 2016.35
R2683 avss.n1216 avss.n341 2016.35
R2684 avss.n1215 avss.n341 2016.35
R2685 avss.n1364 avss.n144 2016.35
R2686 avss.n1365 avss.n144 2016.35
R2687 avss.n66 avss.n137 2016.35
R2688 avss.n1369 avss.n66 2016.35
R2689 avss.n1389 avss.n116 2016.35
R2690 avss.n1390 avss.n116 2016.35
R2691 avss.n1376 avss.n135 2016.35
R2692 avss.n1375 avss.n135 2016.35
R2693 avss.n1305 avss.n204 2016.35
R2694 avss.n511 avss.n204 2016.35
R2695 avss.n1321 avss.n186 2016.35
R2696 avss.n1321 avss.n185 2016.35
R2697 avss.n531 avss.n497 2016.35
R2698 avss.n531 avss.n496 2016.35
R2699 avss.n520 avss.n60 2016.35
R2700 avss.n518 avss.n60 2016.35
R2701 avss.n915 avss.n868 2016.35
R2702 avss.n914 avss.n868 2016.35
R2703 avss.n929 avss.n851 2016.35
R2704 avss.n929 avss.n850 2016.35
R2705 avss.n908 avss.n870 2016.35
R2706 avss.n908 avss.n869 2016.35
R2707 avss.n891 avss.n887 2016.35
R2708 avss.n890 avss.n887 2016.35
R2709 avss.n832 avss.n828 2016.35
R2710 avss.n831 avss.n828 2016.35
R2711 avss.n846 avss.n811 2016.35
R2712 avss.n846 avss.n810 2016.35
R2713 avss.n643 avss.n622 2016.35
R2714 avss.n644 avss.n622 2016.35
R2715 avss.n648 avss.n613 2016.35
R2716 avss.n648 avss.n612 2016.35
R2717 avss.n1349 avss.n159 2016.35
R2718 avss.n1349 avss.n158 2016.35
R2719 avss.n806 avss.n776 2016.35
R2720 avss.n806 avss.n775 2016.35
R2721 avss.n743 avss.n709 2016.35
R2722 avss.n743 avss.n708 2016.35
R2723 avss.n726 avss.n725 2016.35
R2724 avss.n727 avss.n725 2016.35
R2725 avss.n848 avss.n847 1943.97
R2726 avss.n931 avss.n930 1943.97
R2727 avss.n773 avss.n772 1939.22
R2728 avss.n808 avss.n807 1939.22
R2729 avss.n1266 avss.n264 1939.22
R2730 avss.n1269 avss.n1268 1939.22
R2731 avss.n1262 avss.n268 1934.48
R2732 avss.n1264 avss.n266 1934.48
R2733 avss.n748 avss.n747 1796.96
R2734 avss.n1303 avss.n208 1708.61
R2735 avss.n1301 avss.n118 1670.72
R2736 avss.n1345 avss.n1 1667.04
R2737 avss.n1119 avss.n1118 1667.04
R2738 avss.n1119 avss.n283 1663.77
R2739 avss.n2 avss.n1 1663.58
R2740 avss.n1344 avss.n161 1662.36
R2741 avss.n1117 avss.n1116 1662.36
R2742 avss.n1301 avss.n1300 1605.39
R2743 avss.n1303 avss.n210 1581.5
R2744 avss.n1234 avss.n1233 1571.86
R2745 avss.n1303 avss.n1302 1489.02
R2746 avss.n210 avss.n146 1210.41
R2747 avss.n530 avss.n502 1199.38
R2748 avss.n530 avss.n501 1199.38
R2749 avss.n525 avss.n500 1199.38
R2750 avss.n505 avss.n500 1199.38
R2751 avss.n504 avss.n499 1199.38
R2752 avss.n517 avss.n499 1199.38
R2753 avss.n809 avss.n649 1125
R2754 avss.n1265 avss.n265 1122.22
R2755 avss.n102 avss.n100 1100.88
R2756 avss.n102 avss.n96 1100.88
R2757 avss.n659 avss.n655 1100.88
R2758 avss.n660 avss.n659 1100.88
R2759 avss.n692 avss.n687 1100.88
R2760 avss.n692 avss.n685 1100.88
R2761 avss.n683 avss.n676 1100.88
R2762 avss.n683 avss.n680 1100.88
R2763 avss.n681 avss.n677 1100.88
R2764 avss.n682 avss.n681 1100.88
R2765 avss.n177 avss.n176 1100.88
R2766 avss.n176 avss.n172 1100.88
R2767 avss.n1325 avss.n166 1100.88
R2768 avss.n184 avss.n166 1100.88
R2769 avss.n183 avss.n179 1100.88
R2770 avss.n1328 avss.n183 1100.88
R2771 avss.n587 avss.n586 1100.88
R2772 avss.n587 avss.n584 1100.88
R2773 avss.n580 avss.n572 1100.88
R2774 avss.n580 avss.n577 1100.88
R2775 avss.n578 avss.n573 1100.88
R2776 avss.n579 avss.n578 1100.88
R2777 avss.n949 avss.n948 1100.88
R2778 avss.n949 avss.n598 1100.88
R2779 avss.n602 avss.n599 1100.88
R2780 avss.n602 avss.n601 1100.88
R2781 avss.n608 avss.n606 1100.88
R2782 avss.n608 avss.n604 1100.88
R2783 avss.n1030 avss.n555 1100.88
R2784 avss.n1031 avss.n1030 1100.88
R2785 avss.n1019 avss.n564 1100.88
R2786 avss.n1012 avss.n564 1100.88
R2787 avss.n1025 avss.n563 1100.88
R2788 avss.n1025 avss.n562 1100.88
R2789 avss.n1166 avss.n1163 1100.88
R2790 avss.n1166 avss.n1165 1100.88
R2791 avss.n303 avss.n300 1100.88
R2792 avss.n303 avss.n302 1100.88
R2793 avss.n292 avss.n289 1100.88
R2794 avss.n292 avss.n291 1100.88
R2795 avss.n298 avss.n297 1100.88
R2796 avss.n298 avss.n295 1100.88
R2797 avss.n1240 avss.n274 1100.88
R2798 avss.n1240 avss.n278 1100.88
R2799 avss.n1243 avss.n275 1100.88
R2800 avss.n1243 avss.n279 1100.88
R2801 avss.n1249 avss.n1248 1100.88
R2802 avss.n1248 avss.n1246 1100.88
R2803 avss.n426 avss.n422 1100.88
R2804 avss.n426 avss.n418 1100.88
R2805 avss.n487 avss.n410 1100.88
R2806 avss.n487 avss.n413 1100.88
R2807 avss.n421 avss.n417 1100.88
R2808 avss.n484 avss.n417 1100.88
R2809 avss.n226 avss.n219 1100.88
R2810 avss.n226 avss.n222 1100.88
R2811 avss.n233 avss.n231 1100.88
R2812 avss.n234 avss.n233 1100.88
R2813 avss.n239 avss.n230 1100.88
R2814 avss.n230 avss.n224 1100.88
R2815 avss.n540 avss.n399 1100.88
R2816 avss.n540 avss.n403 1100.88
R2817 avss.n543 avss.n400 1100.88
R2818 avss.n543 avss.n404 1100.88
R2819 avss.n1075 avss.n393 1100.88
R2820 avss.n1075 avss.n395 1100.88
R2821 avss.n250 avss.n246 1100.88
R2822 avss.n250 avss.n249 1100.88
R2823 avss.n256 avss.n255 1100.88
R2824 avss.n256 avss.n253 1100.88
R2825 avss.n261 avss.n258 1100.88
R2826 avss.n261 avss.n260 1100.88
R2827 avss.n441 avss.n433 1100.88
R2828 avss.n441 avss.n440 1100.88
R2829 avss.n447 avss.n446 1100.88
R2830 avss.n447 avss.n444 1100.88
R2831 avss.n452 avss.n449 1100.88
R2832 avss.n452 avss.n451 1100.88
R2833 avss.n1108 avss.n1082 1100.88
R2834 avss.n1108 avss.n1081 1100.88
R2835 avss.n1091 avss.n1090 1100.88
R2836 avss.n1090 avss.n1085 1100.88
R2837 avss.n1095 avss.n1092 1100.88
R2838 avss.n1095 avss.n1088 1100.88
R2839 avss.n1045 avss.n1039 1100.88
R2840 avss.n1045 avss.n1043 1100.88
R2841 avss.n1055 avss.n1040 1100.88
R2842 avss.n1055 avss.n1044 1100.88
R2843 avss.n1064 avss.n1060 1100.88
R2844 avss.n1060 avss.n1058 1100.88
R2845 avss.n1150 avss.n1122 1100.88
R2846 avss.n1150 avss.n1121 1100.88
R2847 avss.n1140 avss.n1138 1100.88
R2848 avss.n1138 avss.n1134 1100.88
R2849 avss.n1129 avss.n1127 1100.88
R2850 avss.n1130 avss.n1129 1100.88
R2851 avss.n1182 avss.n367 1100.88
R2852 avss.n1182 avss.n369 1100.88
R2853 avss.n374 avss.n373 1100.88
R2854 avss.n374 avss.n371 1100.88
R2855 avss.n1003 avss.n985 1100.88
R2856 avss.n1003 avss.n984 1100.88
R2857 avss.n995 avss.n994 1100.88
R2858 avss.n994 avss.n988 1100.88
R2859 avss.n992 avss.n377 1100.88
R2860 avss.n992 avss.n380 1100.88
R2861 avss.n1204 avss.n348 1100.88
R2862 avss.n1204 avss.n347 1100.88
R2863 avss.n357 avss.n356 1100.88
R2864 avss.n356 avss.n351 1100.88
R2865 avss.n361 avss.n358 1100.88
R2866 avss.n361 avss.n354 1100.88
R2867 avss.n1218 avss.n339 1100.88
R2868 avss.n1218 avss.n337 1100.88
R2869 avss.n334 avss.n327 1100.88
R2870 avss.n334 avss.n331 1100.88
R2871 avss.n332 avss.n328 1100.88
R2872 avss.n333 avss.n332 1100.88
R2873 avss.n156 avss.n155 1100.88
R2874 avss.n155 avss.n138 1100.88
R2875 avss.n154 avss.n150 1100.88
R2876 avss.n1358 avss.n154 1100.88
R2877 avss.n148 avss.n147 1100.88
R2878 avss.n147 avss.n143 1100.88
R2879 avss.n133 avss.n132 1100.88
R2880 avss.n133 avss.n130 1100.88
R2881 avss.n127 avss.n122 1100.88
R2882 avss.n127 avss.n126 1100.88
R2883 avss.n124 avss.n119 1100.88
R2884 avss.n124 avss.n115 1100.88
R2885 avss.n1316 avss.n192 1100.88
R2886 avss.n1316 avss.n191 1100.88
R2887 avss.n200 avss.n199 1100.88
R2888 avss.n199 avss.n195 1100.88
R2889 avss.n205 avss.n201 1100.88
R2890 avss.n205 avss.n197 1100.88
R2891 avss.n104 avss.n101 1100.88
R2892 avss.n104 avss.n97 1100.88
R2893 avss.n109 avss.n107 1100.88
R2894 avss.n1398 avss.n109 1100.88
R2895 avss.n857 avss.n853 1100.88
R2896 avss.n858 avss.n857 1100.88
R2897 avss.n861 avss.n854 1100.88
R2898 avss.n861 avss.n859 1100.88
R2899 avss.n866 avss.n865 1100.88
R2900 avss.n866 avss.n863 1100.88
R2901 avss.n893 avss.n886 1100.88
R2902 avss.n893 avss.n884 1100.88
R2903 avss.n880 avss.n873 1100.88
R2904 avss.n880 avss.n877 1100.88
R2905 avss.n878 avss.n874 1100.88
R2906 avss.n879 avss.n878 1100.88
R2907 avss.n817 avss.n813 1100.88
R2908 avss.n818 avss.n817 1100.88
R2909 avss.n821 avss.n814 1100.88
R2910 avss.n821 avss.n819 1100.88
R2911 avss.n826 avss.n825 1100.88
R2912 avss.n826 avss.n823 1100.88
R2913 avss.n634 avss.n615 1100.88
R2914 avss.n632 avss.n615 1100.88
R2915 avss.n631 avss.n627 1100.88
R2916 avss.n637 avss.n631 1100.88
R2917 avss.n625 avss.n624 1100.88
R2918 avss.n624 avss.n621 1100.88
R2919 avss.n795 avss.n778 1100.88
R2920 avss.n793 avss.n778 1100.88
R2921 avss.n796 avss.n792 1100.88
R2922 avss.n799 avss.n792 1100.88
R2923 avss.n802 avss.n785 1100.88
R2924 avss.n802 avss.n784 1100.88
R2925 avss.n724 avss.n723 1100.88
R2926 avss.n724 avss.n721 1100.88
R2927 avss.n719 avss.n712 1100.88
R2928 avss.n719 avss.n716 1100.88
R2929 avss.n717 avss.n713 1100.88
R2930 avss.n718 avss.n717 1100.88
R2931 avss.n663 avss.n656 1100.88
R2932 avss.n663 avss.n661 1100.88
R2933 avss.n668 avss.n667 1100.88
R2934 avss.n668 avss.n665 1100.88
R2935 avss.n888 avss.n849 1095.93
R2936 avss.n774 avss.n650 1093.22
R2937 avss.n1267 avss.n263 1093.22
R2938 avss.n1263 avss.n267 1090.51
R2939 avss.n567 avss.n207 1045.65
R2940 avss.n1396 avss.n107 915.471
R2941 avss.n1401 avss.n107 915.471
R2942 avss.n1401 avss.n101 915.471
R2943 avss.n1405 avss.n101 915.471
R2944 avss.n1405 avss.n100 915.471
R2945 avss.n751 avss.n100 915.471
R2946 avss.n1398 avss.n1397 915.471
R2947 avss.n1400 avss.n1398 915.471
R2948 avss.n1400 avss.n97 915.471
R2949 avss.n1406 avss.n97 915.471
R2950 avss.n1406 avss.n96 915.471
R2951 avss.n750 avss.n96 915.471
R2952 avss.n757 avss.n667 915.471
R2953 avss.n761 avss.n667 915.471
R2954 avss.n761 avss.n656 915.471
R2955 avss.n767 avss.n656 915.471
R2956 avss.n767 avss.n655 915.471
R2957 avss.n655 avss.n653 915.471
R2958 avss.n756 avss.n665 915.471
R2959 avss.n762 avss.n665 915.471
R2960 avss.n762 avss.n661 915.471
R2961 avss.n766 avss.n661 915.471
R2962 avss.n766 avss.n660 915.471
R2963 avss.n660 avss.n652 915.471
R2964 avss.n677 avss.n674 915.471
R2965 avss.n701 avss.n677 915.471
R2966 avss.n701 avss.n676 915.471
R2967 avss.n695 avss.n676 915.471
R2968 avss.n695 avss.n687 915.471
R2969 avss.n689 avss.n687 915.471
R2970 avss.n682 avss.n673 915.471
R2971 avss.n700 avss.n682 915.471
R2972 avss.n700 avss.n680 915.471
R2973 avss.n696 avss.n680 915.471
R2974 avss.n696 avss.n685 915.471
R2975 avss.n690 avss.n685 915.471
R2976 avss.n1335 avss.n177 915.471
R2977 avss.n1330 avss.n177 915.471
R2978 avss.n1330 avss.n179 915.471
R2979 avss.n1326 avss.n179 915.471
R2980 avss.n1326 avss.n1325 915.471
R2981 avss.n1325 avss.n163 915.471
R2982 avss.n1336 avss.n172 915.471
R2983 avss.n1329 avss.n172 915.471
R2984 avss.n1329 avss.n1328 915.471
R2985 avss.n1328 avss.n1327 915.471
R2986 avss.n1327 avss.n184 915.471
R2987 avss.n184 avss.n162 915.471
R2988 avss.n573 avss.n569 915.471
R2989 avss.n971 avss.n573 915.471
R2990 avss.n971 avss.n572 915.471
R2991 avss.n966 avss.n572 915.471
R2992 avss.n966 avss.n586 915.471
R2993 avss.n962 avss.n586 915.471
R2994 avss.n579 avss.n568 915.471
R2995 avss.n970 avss.n579 915.471
R2996 avss.n970 avss.n577 915.471
R2997 avss.n967 avss.n577 915.471
R2998 avss.n967 avss.n584 915.471
R2999 avss.n961 avss.n584 915.471
R3000 avss.n937 avss.n606 915.471
R3001 avss.n941 avss.n606 915.471
R3002 avss.n941 avss.n599 915.471
R3003 avss.n947 avss.n599 915.471
R3004 avss.n948 avss.n947 915.471
R3005 avss.n948 avss.n594 915.471
R3006 avss.n936 avss.n604 915.471
R3007 avss.n942 avss.n604 915.471
R3008 avss.n942 avss.n601 915.471
R3009 avss.n946 avss.n601 915.471
R3010 avss.n946 avss.n598 915.471
R3011 avss.n598 avss.n593 915.471
R3012 avss.n1033 avss.n555 915.471
R3013 avss.n1023 avss.n555 915.471
R3014 avss.n1023 avss.n563 915.471
R3015 avss.n1020 avss.n563 915.471
R3016 avss.n1020 avss.n1019 915.471
R3017 avss.n1019 avss.n1018 915.471
R3018 avss.n1032 avss.n1031 915.471
R3019 avss.n1031 avss.n559 915.471
R3020 avss.n562 avss.n559 915.471
R3021 avss.n1011 avss.n562 915.471
R3022 avss.n1012 avss.n1011 915.471
R3023 avss.n1017 avss.n1012 915.471
R3024 avss.n1169 avss.n1163 915.471
R3025 avss.n1175 avss.n1163 915.471
R3026 avss.n1175 avss.n373 915.471
R3027 avss.n1179 avss.n373 915.471
R3028 avss.n1179 avss.n367 915.471
R3029 avss.n1187 avss.n367 915.471
R3030 avss.n1170 avss.n1165 915.471
R3031 avss.n1174 avss.n1165 915.471
R3032 avss.n1174 avss.n371 915.471
R3033 avss.n1180 avss.n371 915.471
R3034 avss.n1180 avss.n369 915.471
R3035 avss.n1186 avss.n369 915.471
R3036 avss.n306 avss.n300 915.471
R3037 avss.n312 avss.n300 915.471
R3038 avss.n312 avss.n297 915.471
R3039 avss.n316 avss.n297 915.471
R3040 avss.n316 avss.n289 915.471
R3041 avss.n322 avss.n289 915.471
R3042 avss.n307 avss.n302 915.471
R3043 avss.n311 avss.n302 915.471
R3044 avss.n311 avss.n295 915.471
R3045 avss.n317 avss.n295 915.471
R3046 avss.n317 avss.n291 915.471
R3047 avss.n321 avss.n291 915.471
R3048 avss.n1249 avss.n270 915.471
R3049 avss.n1250 avss.n1249 915.471
R3050 avss.n1250 avss.n275 915.471
R3051 avss.n1256 avss.n275 915.471
R3052 avss.n1256 avss.n274 915.471
R3053 avss.n1237 avss.n274 915.471
R3054 avss.n1246 avss.n269 915.471
R3055 avss.n1251 avss.n1246 915.471
R3056 avss.n1251 avss.n279 915.471
R3057 avss.n1255 avss.n279 915.471
R3058 avss.n1255 avss.n278 915.471
R3059 avss.n1238 avss.n278 915.471
R3060 avss.n478 avss.n422 915.471
R3061 avss.n482 avss.n422 915.471
R3062 avss.n482 avss.n421 915.471
R3063 avss.n421 avss.n416 915.471
R3064 avss.n416 avss.n410 915.471
R3065 avss.n492 avss.n410 915.471
R3066 avss.n477 avss.n418 915.471
R3067 avss.n483 avss.n418 915.471
R3068 avss.n484 avss.n483 915.471
R3069 avss.n485 avss.n484 915.471
R3070 avss.n485 avss.n413 915.471
R3071 avss.n491 avss.n413 915.471
R3072 avss.n1293 avss.n219 915.471
R3073 avss.n240 avss.n219 915.471
R3074 avss.n240 avss.n239 915.471
R3075 avss.n239 avss.n238 915.471
R3076 avss.n238 avss.n231 915.471
R3077 avss.n231 avss.n214 915.471
R3078 avss.n1292 avss.n222 915.471
R3079 avss.n241 avss.n222 915.471
R3080 avss.n241 avss.n224 915.471
R3081 avss.n237 avss.n224 915.471
R3082 avss.n237 avss.n234 915.471
R3083 avss.n234 avss.n213 915.471
R3084 avss.n1077 avss.n393 915.471
R3085 avss.n545 avss.n393 915.471
R3086 avss.n545 avss.n400 915.471
R3087 avss.n551 avss.n400 915.471
R3088 avss.n551 avss.n399 915.471
R3089 avss.n537 avss.n399 915.471
R3090 avss.n395 avss.n392 915.471
R3091 avss.n546 avss.n395 915.471
R3092 avss.n546 avss.n404 915.471
R3093 avss.n550 avss.n404 915.471
R3094 avss.n550 avss.n403 915.471
R3095 avss.n538 avss.n403 915.471
R3096 avss.n1271 avss.n258 915.471
R3097 avss.n1277 avss.n258 915.471
R3098 avss.n1277 avss.n255 915.471
R3099 avss.n1281 avss.n255 915.471
R3100 avss.n1281 avss.n246 915.471
R3101 avss.n1287 avss.n246 915.471
R3102 avss.n1272 avss.n260 915.471
R3103 avss.n1276 avss.n260 915.471
R3104 avss.n1276 avss.n253 915.471
R3105 avss.n1282 avss.n253 915.471
R3106 avss.n1282 avss.n249 915.471
R3107 avss.n1286 avss.n249 915.471
R3108 avss.n455 avss.n449 915.471
R3109 avss.n461 avss.n449 915.471
R3110 avss.n461 avss.n446 915.471
R3111 avss.n465 avss.n446 915.471
R3112 avss.n465 avss.n433 915.471
R3113 avss.n471 avss.n433 915.471
R3114 avss.n456 avss.n451 915.471
R3115 avss.n460 avss.n451 915.471
R3116 avss.n460 avss.n444 915.471
R3117 avss.n466 avss.n444 915.471
R3118 avss.n466 avss.n440 915.471
R3119 avss.n470 avss.n440 915.471
R3120 avss.n1098 avss.n1092 915.471
R3121 avss.n1101 avss.n1092 915.471
R3122 avss.n1101 avss.n1091 915.471
R3123 avss.n1091 avss.n1084 915.471
R3124 avss.n1084 avss.n1082 915.471
R3125 avss.n1082 avss.n389 915.471
R3126 avss.n1097 avss.n1088 915.471
R3127 avss.n1102 avss.n1088 915.471
R3128 avss.n1102 avss.n1085 915.471
R3129 avss.n1106 avss.n1085 915.471
R3130 avss.n1106 avss.n1081 915.471
R3131 avss.n1081 avss.n388 915.471
R3132 avss.n1064 avss.n1063 915.471
R3133 avss.n1066 avss.n1064 915.471
R3134 avss.n1066 avss.n1040 915.471
R3135 avss.n1072 avss.n1040 915.471
R3136 avss.n1072 avss.n1039 915.471
R3137 avss.n1051 avss.n1039 915.471
R3138 avss.n1062 avss.n1058 915.471
R3139 avss.n1067 avss.n1058 915.471
R3140 avss.n1067 avss.n1044 915.471
R3141 avss.n1071 avss.n1044 915.471
R3142 avss.n1071 avss.n1043 915.471
R3143 avss.n1052 avss.n1043 915.471
R3144 avss.n1147 avss.n1127 915.471
R3145 avss.n1141 avss.n1127 915.471
R3146 avss.n1141 avss.n1140 915.471
R3147 avss.n1140 avss.n1139 915.471
R3148 avss.n1139 avss.n1122 915.471
R3149 avss.n1122 avss.n384 915.471
R3150 avss.n1146 avss.n1130 915.471
R3151 avss.n1142 avss.n1130 915.471
R3152 avss.n1142 avss.n1134 915.471
R3153 avss.n1134 avss.n1133 915.471
R3154 avss.n1133 avss.n1121 915.471
R3155 avss.n1121 avss.n383 915.471
R3156 avss.n1159 avss.n377 915.471
R3157 avss.n996 avss.n377 915.471
R3158 avss.n996 avss.n995 915.471
R3159 avss.n995 avss.n987 915.471
R3160 avss.n987 avss.n985 915.471
R3161 avss.n985 avss.n981 915.471
R3162 avss.n1158 avss.n380 915.471
R3163 avss.n997 avss.n380 915.471
R3164 avss.n997 avss.n988 915.471
R3165 avss.n1001 avss.n988 915.471
R3166 avss.n1001 avss.n984 915.471
R3167 avss.n984 avss.n980 915.471
R3168 avss.n1194 avss.n358 915.471
R3169 avss.n1197 avss.n358 915.471
R3170 avss.n1197 avss.n357 915.471
R3171 avss.n357 avss.n350 915.471
R3172 avss.n350 avss.n348 915.471
R3173 avss.n348 avss.n344 915.471
R3174 avss.n1193 avss.n354 915.471
R3175 avss.n1198 avss.n354 915.471
R3176 avss.n1198 avss.n351 915.471
R3177 avss.n1202 avss.n351 915.471
R3178 avss.n1202 avss.n347 915.471
R3179 avss.n347 avss.n343 915.471
R3180 avss.n328 avss.n286 915.471
R3181 avss.n1229 avss.n328 915.471
R3182 avss.n1229 avss.n327 915.471
R3183 avss.n1221 avss.n327 915.471
R3184 avss.n1221 avss.n339 915.471
R3185 avss.n1216 avss.n339 915.471
R3186 avss.n333 avss.n285 915.471
R3187 avss.n1228 avss.n333 915.471
R3188 avss.n1228 avss.n331 915.471
R3189 avss.n1222 avss.n331 915.471
R3190 avss.n1222 avss.n337 915.471
R3191 avss.n1215 avss.n337 915.471
R3192 avss.n1364 avss.n148 915.471
R3193 avss.n1360 avss.n148 915.471
R3194 avss.n1360 avss.n150 915.471
R3195 avss.n1356 avss.n150 915.471
R3196 avss.n1356 avss.n156 915.471
R3197 avss.n156 avss.n137 915.471
R3198 avss.n1365 avss.n143 915.471
R3199 avss.n1359 avss.n143 915.471
R3200 avss.n1359 avss.n1358 915.471
R3201 avss.n1358 avss.n1357 915.471
R3202 avss.n1357 avss.n138 915.471
R3203 avss.n1369 avss.n138 915.471
R3204 avss.n1389 avss.n119 915.471
R3205 avss.n1385 avss.n119 915.471
R3206 avss.n1385 avss.n122 915.471
R3207 avss.n1380 avss.n122 915.471
R3208 avss.n1380 avss.n132 915.471
R3209 avss.n1376 avss.n132 915.471
R3210 avss.n1390 avss.n115 915.471
R3211 avss.n1384 avss.n115 915.471
R3212 avss.n1384 avss.n126 915.471
R3213 avss.n1381 avss.n126 915.471
R3214 avss.n1381 avss.n130 915.471
R3215 avss.n1375 avss.n130 915.471
R3216 avss.n1305 avss.n201 915.471
R3217 avss.n1309 avss.n201 915.471
R3218 avss.n1309 avss.n200 915.471
R3219 avss.n200 avss.n194 915.471
R3220 avss.n194 avss.n192 915.471
R3221 avss.n192 avss.n186 915.471
R3222 avss.n511 avss.n197 915.471
R3223 avss.n1310 avss.n197 915.471
R3224 avss.n1310 avss.n195 915.471
R3225 avss.n1314 avss.n195 915.471
R3226 avss.n1314 avss.n191 915.471
R3227 avss.n191 avss.n185 915.471
R3228 avss.n915 avss.n865 915.471
R3229 avss.n919 avss.n865 915.471
R3230 avss.n919 avss.n854 915.471
R3231 avss.n925 avss.n854 915.471
R3232 avss.n925 avss.n853 915.471
R3233 avss.n853 avss.n851 915.471
R3234 avss.n914 avss.n863 915.471
R3235 avss.n920 avss.n863 915.471
R3236 avss.n920 avss.n859 915.471
R3237 avss.n924 avss.n859 915.471
R3238 avss.n924 avss.n858 915.471
R3239 avss.n858 avss.n850 915.471
R3240 avss.n874 avss.n870 915.471
R3241 avss.n903 avss.n874 915.471
R3242 avss.n903 avss.n873 915.471
R3243 avss.n896 avss.n873 915.471
R3244 avss.n896 avss.n886 915.471
R3245 avss.n891 avss.n886 915.471
R3246 avss.n879 avss.n869 915.471
R3247 avss.n902 avss.n879 915.471
R3248 avss.n902 avss.n877 915.471
R3249 avss.n897 avss.n877 915.471
R3250 avss.n897 avss.n884 915.471
R3251 avss.n890 avss.n884 915.471
R3252 avss.n832 avss.n825 915.471
R3253 avss.n836 avss.n825 915.471
R3254 avss.n836 avss.n814 915.471
R3255 avss.n842 avss.n814 915.471
R3256 avss.n842 avss.n813 915.471
R3257 avss.n813 avss.n811 915.471
R3258 avss.n831 avss.n823 915.471
R3259 avss.n837 avss.n823 915.471
R3260 avss.n837 avss.n819 915.471
R3261 avss.n841 avss.n819 915.471
R3262 avss.n841 avss.n818 915.471
R3263 avss.n818 avss.n810 915.471
R3264 avss.n643 avss.n625 915.471
R3265 avss.n639 avss.n625 915.471
R3266 avss.n639 avss.n627 915.471
R3267 avss.n635 avss.n627 915.471
R3268 avss.n635 avss.n634 915.471
R3269 avss.n634 avss.n613 915.471
R3270 avss.n644 avss.n621 915.471
R3271 avss.n638 avss.n621 915.471
R3272 avss.n638 avss.n637 915.471
R3273 avss.n637 avss.n636 915.471
R3274 avss.n636 avss.n632 915.471
R3275 avss.n632 avss.n612 915.471
R3276 avss.n785 avss.n159 915.471
R3277 avss.n787 avss.n785 915.471
R3278 avss.n796 avss.n787 915.471
R3279 avss.n797 avss.n796 915.471
R3280 avss.n797 avss.n795 915.471
R3281 avss.n795 avss.n776 915.471
R3282 avss.n784 avss.n158 915.471
R3283 avss.n800 avss.n784 915.471
R3284 avss.n800 avss.n799 915.471
R3285 avss.n799 avss.n798 915.471
R3286 avss.n798 avss.n793 915.471
R3287 avss.n793 avss.n775 915.471
R3288 avss.n713 avss.n709 915.471
R3289 avss.n738 avss.n713 915.471
R3290 avss.n738 avss.n712 915.471
R3291 avss.n731 avss.n712 915.471
R3292 avss.n731 avss.n723 915.471
R3293 avss.n726 avss.n723 915.471
R3294 avss.n718 avss.n708 915.471
R3295 avss.n737 avss.n718 915.471
R3296 avss.n737 avss.n716 915.471
R3297 avss.n732 avss.n716 915.471
R3298 avss.n732 avss.n721 915.471
R3299 avss.n727 avss.n721 915.471
R3300 avss.n979 avss.n978 866.659
R3301 avss.n526 avss.n525 816.971
R3302 avss.n526 avss.n502 816.971
R3303 avss.n502 avss.n497 816.971
R3304 avss.n501 avss.n496 816.971
R3305 avss.n517 avss.n516 816.971
R3306 avss.n516 avss.n505 816.971
R3307 avss.n507 avss.n505 816.971
R3308 avss.n507 avss.n501 816.971
R3309 avss.n520 avss.n504 816.971
R3310 avss.n524 avss.n504 816.971
R3311 avss.n525 avss.n524 816.971
R3312 avss.n518 avss.n517 816.971
R3313 avss.t165 avss.n671 749.139
R3314 avss.t165 avss.n666 749.139
R3315 avss.t71 avss.n666 749.139
R3316 avss.t71 avss.n658 749.139
R3317 avss.t72 avss.n658 749.139
R3318 avss.t72 avss.n657 749.139
R3319 avss.n657 avss.t86 749.139
R3320 avss.n772 avss.t86 749.139
R3321 avss.n1348 avss.t170 749.139
R3322 avss.n801 avss.t170 749.139
R3323 avss.n801 avss.t17 749.139
R3324 avss.t17 avss.n786 749.139
R3325 avss.t18 avss.n786 749.139
R3326 avss.t18 avss.n794 749.139
R3327 avss.n794 avss.t92 749.139
R3328 avss.n807 avss.t92 749.139
R3329 avss.t174 avss.n829 749.139
R3330 avss.t174 avss.n824 749.139
R3331 avss.t37 avss.n824 749.139
R3332 avss.t37 avss.n816 749.139
R3333 avss.t38 avss.n816 749.139
R3334 avss.t38 avss.n815 749.139
R3335 avss.n815 avss.t98 749.139
R3336 avss.n847 avss.t98 749.139
R3337 avss.t54 avss.n912 749.139
R3338 avss.t54 avss.n864 749.139
R3339 avss.t43 avss.n864 749.139
R3340 avss.t43 avss.n856 749.139
R3341 avss.t44 avss.n856 749.139
R3342 avss.t44 avss.n855 749.139
R3343 avss.n855 avss.t100 749.139
R3344 avss.n930 avss.t100 749.139
R3345 avss.t78 avss.n268 749.139
R3346 avss.t78 avss.n301 749.139
R3347 avss.t62 avss.n301 749.139
R3348 avss.t62 avss.n296 749.139
R3349 avss.t64 avss.n296 749.139
R3350 avss.t64 avss.n290 749.139
R3351 avss.t33 avss.n290 749.139
R3352 avss.t33 avss.n284 749.139
R3353 avss.t104 avss.n266 749.139
R3354 avss.t104 avss.n1128 749.139
R3355 avss.t147 avss.n1128 749.139
R3356 avss.t147 avss.n1135 749.139
R3357 avss.n1135 avss.t151 749.139
R3358 avss.n1151 avss.t151 749.139
R3359 avss.t53 avss.n1151 749.139
R3360 avss.n1152 avss.t53 749.139
R3361 avss.t96 avss.n264 749.139
R3362 avss.t96 avss.n1089 749.139
R3363 avss.t6 avss.n1089 749.139
R3364 avss.t6 avss.n1083 749.139
R3365 avss.t139 avss.n1083 749.139
R3366 avss.n1107 avss.t139 749.139
R3367 avss.n1107 avss.t114 749.139
R3368 avss.n1114 avss.t114 749.139
R3369 avss.t88 avss.n1269 749.139
R3370 avss.t88 avss.n259 749.139
R3371 avss.t0 avss.n259 749.139
R3372 avss.t0 avss.n254 749.139
R3373 avss.t57 avss.n254 749.139
R3374 avss.t57 avss.n248 749.139
R3375 avss.t61 avss.n248 749.139
R3376 avss.t61 avss.n247 749.139
R3377 avss.t182 avss.n1035 729.601
R3378 avss.t161 avss.n362 729.601
R3379 avss.t159 avss.n427 729.601
R3380 avss.n510 avss.n198 716.279
R3381 avss.t69 avss.n498 664.818
R3382 avss.t69 avss.n209 664.818
R3383 avss.n411 avss.n211 640.462
R3384 avss.n707 avss.t146 629.14
R3385 avss.n679 avss.t146 629.14
R3386 avss.t65 avss.n679 629.14
R3387 avss.t65 avss.n678 629.14
R3388 avss.t66 avss.n678 629.14
R3389 avss.t66 avss.n686 629.14
R3390 avss.t84 avss.n686 629.14
R3391 avss.t84 avss.n651 629.14
R3392 avss.n1261 avss.t108 629.14
R3393 avss.n1247 avss.t108 629.14
R3394 avss.t168 avss.n1247 629.14
R3395 avss.t168 avss.n277 629.14
R3396 avss.t60 avss.n277 629.14
R3397 avss.t60 avss.n276 629.14
R3398 avss.t167 avss.n276 629.14
R3399 avss.t167 avss.n1235 629.14
R3400 avss.n1344 avss.n1343 590.034
R3401 avss.n1117 avss.n386 590.034
R3402 avss.t171 avss.n193 588.157
R3403 avss.t172 avss.n193 588.157
R3404 avss.n1315 avss.t172 588.157
R3405 avss.n1315 avss.t179 588.157
R3406 avss.n1322 avss.t179 588.157
R3407 avss.t181 avss.n558 588.157
R3408 avss.t181 avss.n557 588.157
R3409 avss.t46 avss.n557 588.157
R3410 avss.n1024 avss.t46 588.157
R3411 avss.n1024 avss.t110 588.157
R3412 avss.n379 avss.n283 581.966
R3413 avss.n2 avss.n0 581.347
R3414 avss.t42 avss.n934 557.946
R3415 avss.t42 avss.n605 557.946
R3416 avss.t176 avss.n605 557.946
R3417 avss.t176 avss.n600 557.946
R3418 avss.t177 avss.n600 557.946
R3419 avss.t177 avss.n590 557.946
R3420 avss.t112 avss.n993 557.946
R3421 avss.t112 avss.n986 557.946
R3422 avss.t132 avss.n986 557.946
R3423 avss.n1002 avss.t132 557.946
R3424 avss.n1002 avss.t35 557.946
R3425 avss.n1008 avss.t35 557.946
R3426 avss.t10 avss.n227 557.946
R3427 avss.t10 avss.n225 557.946
R3428 avss.t26 avss.n225 557.946
R3429 avss.t26 avss.n232 557.946
R3430 avss.n232 avss.t2 557.946
R3431 avss.n1299 avss.t2 557.946
R3432 avss.t68 avss.n146 557.946
R3433 avss.t68 avss.n145 557.946
R3434 avss.t141 avss.n145 557.946
R3435 avss.t141 avss.n151 557.946
R3436 avss.t142 avss.n151 557.946
R3437 avss.t142 avss.n136 557.946
R3438 avss.n910 avss.n592 548.071
R3439 avss.n437 avss.n436 548.071
R3440 avss.n1036 avss.n554 536.923
R3441 avss.n1192 avss.n1191 536.923
R3442 avss.n476 avss.n475 536.923
R3443 avss.n1319 avss.n1318 534.362
R3444 avss.n963 avss.n588 534.362
R3445 avss.n1377 avss.n134 534.362
R3446 avss.t23 avss.n576 533.13
R3447 avss.t23 avss.n574 533.13
R3448 avss.t24 avss.n574 533.13
R3449 avss.t24 avss.n585 533.13
R3450 avss.t154 avss.n585 533.13
R3451 avss.t154 avss.n957 533.13
R3452 avss.t160 avss.n364 533.13
R3453 avss.t160 avss.n355 533.13
R3454 avss.t133 avss.n355 533.13
R3455 avss.t133 avss.n349 533.13
R3456 avss.t49 avss.n349 533.13
R3457 avss.n1203 avss.t49 533.13
R3458 avss.t158 avss.n429 533.13
R3459 avss.t158 avss.n420 533.13
R3460 avss.t27 avss.n420 533.13
R3461 avss.t27 avss.n415 533.13
R3462 avss.t136 avss.n415 533.13
R3463 avss.n486 avss.t136 533.13
R3464 avss.t74 avss.n125 533.13
R3465 avss.t74 avss.n123 533.13
R3466 avss.t75 avss.n123 533.13
R3467 avss.t75 avss.n131 533.13
R3468 avss.t156 avss.n131 533.13
R3469 avss.t156 avss.n1371 533.13
R3470 avss.t36 avss.n175 522.707
R3471 avss.t36 avss.n174 522.707
R3472 avss.t162 avss.n174 522.707
R3473 avss.t162 avss.n180 522.707
R3474 avss.t163 avss.n180 522.707
R3475 avss.t144 avss.n402 522.707
R3476 avss.t48 avss.n402 522.707
R3477 avss.t48 avss.n401 522.707
R3478 avss.t166 avss.n401 522.707
R3479 avss.t166 avss.n407 522.707
R3480 avss.n1346 avss.n1345 512.131
R3481 avss.n1118 avss.n385 512.131
R3482 avss.n745 avss.n2 505.587
R3483 avss.t140 avss.n208 488.175
R3484 avss.t180 avss.n187 471.041
R3485 avss.n959 avss.t155 471.041
R3486 avss.n1373 avss.t157 471.041
R3487 avss.n1303 avss.n209 456.058
R3488 avss.n978 avss.n342 445.471
R3489 avss.n1203 avss.t9 444.433
R3490 avss.t31 avss.n160 438.889
R3491 avss.t31 avss.n623 438.889
R3492 avss.t20 avss.n623 438.889
R3493 avss.t20 avss.n628 438.889
R3494 avss.t21 avss.n628 438.889
R3495 avss.t21 avss.n633 438.889
R3496 avss.n633 avss.t82 438.889
R3497 avss.n649 avss.t82 438.889
R3498 avss.t94 avss.n265 438.889
R3499 avss.t94 avss.n1059 438.889
R3500 avss.t149 avss.n1059 438.889
R3501 avss.t149 avss.n1042 438.889
R3502 avss.t40 avss.n1042 438.889
R3503 avss.t40 avss.n1041 438.889
R3504 avss.t30 avss.n1041 438.889
R3505 avss.t30 avss.n1049 438.889
R3506 avss.n744 avss.t12 428.608
R3507 avss.n715 avss.t12 428.608
R3508 avss.t13 avss.n715 428.608
R3509 avss.t13 avss.n714 428.608
R3510 avss.t14 avss.n714 428.608
R3511 avss.t14 avss.n722 428.608
R3512 avss.t80 avss.n722 428.608
R3513 avss.t80 avss.n650 428.608
R3514 avss.n909 avss.t8 428.608
R3515 avss.n876 avss.t8 428.608
R3516 avss.t50 avss.n876 428.608
R3517 avss.t50 avss.n875 428.608
R3518 avss.t51 avss.n875 428.608
R3519 avss.t51 avss.n885 428.608
R3520 avss.t102 avss.n885 428.608
R3521 avss.t102 avss.n888 428.608
R3522 avss.t106 avss.n267 428.608
R3523 avss.t106 avss.n1164 428.608
R3524 avss.t55 avss.n1164 428.608
R3525 avss.t55 avss.n372 428.608
R3526 avss.t115 avss.n372 428.608
R3527 avss.t115 avss.n368 428.608
R3528 avss.t111 avss.n368 428.608
R3529 avss.t111 avss.n282 428.608
R3530 avss.t90 avss.n263 428.608
R3531 avss.t90 avss.n450 428.608
R3532 avss.t58 avss.n450 428.608
R3533 avss.t58 avss.n445 428.608
R3534 avss.t41 avss.n445 428.608
R3535 avss.t41 avss.n439 428.608
R3536 avss.t32 avss.n439 428.608
R3537 avss.t32 avss.n438 428.608
R3538 avss.n387 avss.n221 398.317
R3539 avss.n955 avss.n954 396.772
R3540 avss.n1234 avss.n283 387.315
R3541 avss.t34 avss.n113 387.298
R3542 avss.t34 avss.n108 387.298
R3543 avss.t3 avss.n108 387.298
R3544 avss.t3 avss.n99 387.298
R3545 avss.t4 avss.n99 387.298
R3546 avss.t4 avss.n98 387.298
R3547 avss.t116 avss.n98 387.298
R3548 avss.t116 avss.n748 387.298
R3549 avss.n1233 avss.t120 387.298
R3550 avss.n330 avss.t120 387.298
R3551 avss.t137 avss.n330 387.298
R3552 avss.t137 avss.n329 387.298
R3553 avss.t77 avss.n329 387.298
R3554 avss.t77 avss.n338 387.298
R3555 avss.t175 avss.n338 387.298
R3556 avss.t175 avss.n1212 387.298
R3557 avss.n1210 avss.t9 377.416
R3558 avss.t135 avss.n411 365.318
R3559 avss.t3 avss.n1400 292.5
R3560 avss.n1400 avss.n1399 292.5
R3561 avss.n1406 avss.t4 292.5
R3562 avss.n1407 avss.n1406 292.5
R3563 avss.n751 avss.t116 292.5
R3564 avss.n752 avss.n751 292.5
R3565 avss.t4 avss.n1405 292.5
R3566 avss.n1405 avss.n1404 292.5
R3567 avss.n1401 avss.t3 292.5
R3568 avss.n1402 avss.n1401 292.5
R3569 avss.t34 avss.n1396 292.5
R3570 avss.n1396 avss.n1395 292.5
R3571 avss.n1397 avss.t34 292.5
R3572 avss.n1397 avss.n112 292.5
R3573 avss.t116 avss.n750 292.5
R3574 avss.n750 avss.n749 292.5
R3575 avss.t165 avss.n756 292.5
R3576 avss.n756 avss.n755 292.5
R3577 avss.n653 avss.t86 292.5
R3578 avss.n770 avss.n653 292.5
R3579 avss.n767 avss.t72 292.5
R3580 avss.n768 avss.n767 292.5
R3581 avss.t71 avss.n761 292.5
R3582 avss.n761 avss.n760 292.5
R3583 avss.n757 avss.t165 292.5
R3584 avss.n758 avss.n757 292.5
R3585 avss.n762 avss.t71 292.5
R3586 avss.n763 avss.n762 292.5
R3587 avss.t72 avss.n766 292.5
R3588 avss.n766 avss.n765 292.5
R3589 avss.n652 avss.t86 292.5
R3590 avss.n662 avss.n652 292.5
R3591 avss.n708 avss.t12 292.5
R3592 avss.n735 avss.n708 292.5
R3593 avss.t13 avss.n737 292.5
R3594 avss.n737 avss.n736 292.5
R3595 avss.n732 avss.t14 292.5
R3596 avss.n733 avss.n732 292.5
R3597 avss.n727 avss.t80 292.5
R3598 avss.n728 avss.n727 292.5
R3599 avss.t80 avss.n726 292.5
R3600 avss.n726 avss.n67 292.5
R3601 avss.t14 avss.n731 292.5
R3602 avss.n731 avss.n730 292.5
R3603 avss.n738 avss.t13 292.5
R3604 avss.n739 avss.n738 292.5
R3605 avss.n709 avss.t12 292.5
R3606 avss.n741 avss.n709 292.5
R3607 avss.t170 avss.n158 292.5
R3608 avss.n158 avss.n49 292.5
R3609 avss.t17 avss.n800 292.5
R3610 avss.n800 avss.n781 292.5
R3611 avss.n798 avss.t18 292.5
R3612 avss.n798 avss.n780 292.5
R3613 avss.n775 avss.t92 292.5
R3614 avss.n779 avss.n775 292.5
R3615 avss.n776 avss.t92 292.5
R3616 avss.n805 avss.n776 292.5
R3617 avss.t18 avss.n797 292.5
R3618 avss.n797 avss.n777 292.5
R3619 avss.t17 avss.n787 292.5
R3620 avss.n789 avss.n787 292.5
R3621 avss.t170 avss.n159 292.5
R3622 avss.n782 avss.n159 292.5
R3623 avss.n644 avss.t31 292.5
R3624 avss.n645 avss.n644 292.5
R3625 avss.t20 avss.n638 292.5
R3626 avss.n638 avss.n618 292.5
R3627 avss.n636 avss.t21 292.5
R3628 avss.n636 avss.n617 292.5
R3629 avss.n612 avss.t82 292.5
R3630 avss.n616 avss.n612 292.5
R3631 avss.n613 avss.t82 292.5
R3632 avss.n647 avss.n613 292.5
R3633 avss.t21 avss.n635 292.5
R3634 avss.n635 avss.n614 292.5
R3635 avss.n639 avss.t20 292.5
R3636 avss.n640 avss.n639 292.5
R3637 avss.t31 avss.n643 292.5
R3638 avss.n643 avss.n642 292.5
R3639 avss.t174 avss.n831 292.5
R3640 avss.n831 avss.n830 292.5
R3641 avss.n837 avss.t37 292.5
R3642 avss.n838 avss.n837 292.5
R3643 avss.t38 avss.n841 292.5
R3644 avss.n841 avss.n840 292.5
R3645 avss.n810 avss.t98 292.5
R3646 avss.n820 avss.n810 292.5
R3647 avss.n811 avss.t98 292.5
R3648 avss.n845 avss.n811 292.5
R3649 avss.n842 avss.t38 292.5
R3650 avss.n843 avss.n842 292.5
R3651 avss.t37 avss.n836 292.5
R3652 avss.n836 avss.n835 292.5
R3653 avss.n832 avss.t174 292.5
R3654 avss.n833 avss.n832 292.5
R3655 avss.n869 avss.t8 292.5
R3656 avss.n883 avss.n869 292.5
R3657 avss.t50 avss.n902 292.5
R3658 avss.n902 avss.n901 292.5
R3659 avss.n897 avss.t51 292.5
R3660 avss.n898 avss.n897 292.5
R3661 avss.t102 avss.n890 292.5
R3662 avss.n890 avss.n889 292.5
R3663 avss.n891 avss.t102 292.5
R3664 avss.n892 avss.n891 292.5
R3665 avss.t51 avss.n896 292.5
R3666 avss.n896 avss.n895 292.5
R3667 avss.n903 avss.t50 292.5
R3668 avss.n904 avss.n903 292.5
R3669 avss.n870 avss.t8 292.5
R3670 avss.n906 avss.n870 292.5
R3671 avss.t54 avss.n914 292.5
R3672 avss.n914 avss.n913 292.5
R3673 avss.n920 avss.t43 292.5
R3674 avss.n921 avss.n920 292.5
R3675 avss.t44 avss.n924 292.5
R3676 avss.n924 avss.n923 292.5
R3677 avss.n850 avss.t100 292.5
R3678 avss.n860 avss.n850 292.5
R3679 avss.n851 avss.t100 292.5
R3680 avss.n928 avss.n851 292.5
R3681 avss.n925 avss.t44 292.5
R3682 avss.n926 avss.n925 292.5
R3683 avss.t43 avss.n919 292.5
R3684 avss.n919 avss.n918 292.5
R3685 avss.n915 avss.t54 292.5
R3686 avss.n916 avss.n915 292.5
R3687 avss.n593 avss.t130 292.5
R3688 avss.n597 avss.n593 292.5
R3689 avss.n594 avss.t130 292.5
R3690 avss.n951 avss.n594 292.5
R3691 avss.n162 avss.t126 292.5
R3692 avss.n167 avss.n162 292.5
R3693 avss.n163 avss.t126 292.5
R3694 avss.n1340 avss.n163 292.5
R3695 avss.t122 avss.n1369 292.5
R3696 avss.n1369 avss.n1368 292.5
R3697 avss.t122 avss.n137 292.5
R3698 avss.n1353 avss.n137 292.5
R3699 avss.n673 avss.t146 292.5
R3700 avss.n8 avss.n673 292.5
R3701 avss.t65 avss.n700 292.5
R3702 avss.n700 avss.n699 292.5
R3703 avss.n696 avss.t66 292.5
R3704 avss.n697 avss.n696 292.5
R3705 avss.n690 avss.t84 292.5
R3706 avss.n691 avss.n690 292.5
R3707 avss.t84 avss.n689 292.5
R3708 avss.n689 avss.n58 292.5
R3709 avss.t66 avss.n695 292.5
R3710 avss.n695 avss.n694 292.5
R3711 avss.n701 avss.t65 292.5
R3712 avss.n702 avss.n701 292.5
R3713 avss.n674 avss.t146 292.5
R3714 avss.n704 avss.n674 292.5
R3715 avss.n1390 avss.t29 292.5
R3716 avss.n1391 avss.n1390 292.5
R3717 avss.t29 avss.n1389 292.5
R3718 avss.n1389 avss.n1388 292.5
R3719 avss.t135 avss.n491 292.5
R3720 avss.n491 avss.n490 292.5
R3721 avss.n492 avss.t135 292.5
R3722 avss.n493 avss.n492 292.5
R3723 avss.n496 avss.n209 292.5
R3724 avss.n496 avss.n33 292.5
R3725 avss.n507 avss.n209 292.5
R3726 avss.n508 avss.n507 292.5
R3727 avss.n516 avss.n209 292.5
R3728 avss.n516 avss.n515 292.5
R3729 avss.n518 avss.n209 292.5
R3730 avss.n519 avss.n518 292.5
R3731 avss.n520 avss.n498 292.5
R3732 avss.n521 avss.n520 292.5
R3733 avss.n524 avss.n498 292.5
R3734 avss.n524 avss.n523 292.5
R3735 avss.n526 avss.n498 292.5
R3736 avss.n527 avss.n526 292.5
R3737 avss.n498 avss.n497 292.5
R3738 avss.n497 avss.n495 292.5
R3739 avss.n511 avss.n510 292.5
R3740 avss.n512 avss.n511 292.5
R3741 avss.n1305 avss.n1304 292.5
R3742 avss.n1306 avss.n1305 292.5
R3743 avss.n1310 avss.t171 292.5
R3744 avss.n1311 avss.n1310 292.5
R3745 avss.t172 avss.n1314 292.5
R3746 avss.n1314 avss.n1313 292.5
R3747 avss.n185 avss.t179 292.5
R3748 avss.n190 avss.n185 292.5
R3749 avss.n186 avss.t179 292.5
R3750 avss.n1318 avss.n186 292.5
R3751 avss.t172 avss.n194 292.5
R3752 avss.n194 avss.n189 292.5
R3753 avss.t171 avss.n1309 292.5
R3754 avss.n1309 avss.n1308 292.5
R3755 avss.t162 avss.n1329 292.5
R3756 avss.n1329 avss.n169 292.5
R3757 avss.n1327 avss.t163 292.5
R3758 avss.n1327 avss.n168 292.5
R3759 avss.t163 avss.n1326 292.5
R3760 avss.n1326 avss.n165 292.5
R3761 avss.n1330 avss.t162 292.5
R3762 avss.n1331 avss.n1330 292.5
R3763 avss.t36 avss.n1335 292.5
R3764 avss.n1335 avss.n1334 292.5
R3765 avss.n1336 avss.t36 292.5
R3766 avss.n1337 avss.n1336 292.5
R3767 avss.n568 avss.t70 292.5
R3768 avss.n583 avss.n568 292.5
R3769 avss.n569 avss.t70 292.5
R3770 avss.n974 avss.n569 292.5
R3771 avss.t42 avss.n936 292.5
R3772 avss.n936 avss.n935 292.5
R3773 avss.n942 avss.t176 292.5
R3774 avss.n943 avss.n942 292.5
R3775 avss.t177 avss.n946 292.5
R3776 avss.n946 avss.n945 292.5
R3777 avss.n947 avss.t177 292.5
R3778 avss.n947 avss.n596 292.5
R3779 avss.t176 avss.n941 292.5
R3780 avss.n941 avss.n940 292.5
R3781 avss.n937 avss.t42 292.5
R3782 avss.n938 avss.n937 292.5
R3783 avss.t154 avss.n961 292.5
R3784 avss.n961 avss.n960 292.5
R3785 avss.n962 avss.t154 292.5
R3786 avss.n963 avss.n962 292.5
R3787 avss.t24 avss.n966 292.5
R3788 avss.n966 avss.n965 292.5
R3789 avss.n971 avss.t23 292.5
R3790 avss.n972 avss.n971 292.5
R3791 avss.t23 avss.n970 292.5
R3792 avss.n970 avss.n969 292.5
R3793 avss.n967 avss.t24 292.5
R3794 avss.n968 avss.n967 292.5
R3795 avss.n343 avss.t9 292.5
R3796 avss.n345 avss.n343 292.5
R3797 avss.n344 avss.t9 292.5
R3798 avss.n1206 avss.n344 292.5
R3799 avss.n285 avss.t120 292.5
R3800 avss.n1225 avss.n285 292.5
R3801 avss.t137 avss.n1228 292.5
R3802 avss.n1228 avss.n1227 292.5
R3803 avss.n1222 avss.t77 292.5
R3804 avss.n1223 avss.n1222 292.5
R3805 avss.t175 avss.n1215 292.5
R3806 avss.n1215 avss.n1214 292.5
R3807 avss.n1216 avss.t175 292.5
R3808 avss.n1217 avss.n1216 292.5
R3809 avss.t77 avss.n1221 292.5
R3810 avss.n1221 avss.n1220 292.5
R3811 avss.n1229 avss.t137 292.5
R3812 avss.n1230 avss.n1229 292.5
R3813 avss.n286 avss.t120 292.5
R3814 avss.n1231 avss.n286 292.5
R3815 avss.t128 avss.n1158 292.5
R3816 avss.n1158 avss.n1157 292.5
R3817 avss.n1159 avss.t128 292.5
R3818 avss.n1160 avss.n1159 292.5
R3819 avss.t160 avss.n1193 292.5
R3820 avss.n1193 avss.n1192 292.5
R3821 avss.n1198 avss.t133 292.5
R3822 avss.n1199 avss.n1198 292.5
R3823 avss.t49 avss.n1202 292.5
R3824 avss.n1202 avss.n1201 292.5
R3825 avss.t49 avss.n350 292.5
R3826 avss.n359 avss.n350 292.5
R3827 avss.t133 avss.n1197 292.5
R3828 avss.n1197 avss.n1196 292.5
R3829 avss.n1194 avss.t160 292.5
R3830 avss.n1195 avss.n1194 292.5
R3831 avss.n997 avss.t112 292.5
R3832 avss.n998 avss.n997 292.5
R3833 avss.t132 avss.n1001 292.5
R3834 avss.n1001 avss.n1000 292.5
R3835 avss.n980 avss.t35 292.5
R3836 avss.n982 avss.n980 292.5
R3837 avss.n981 avss.t35 292.5
R3838 avss.n1005 avss.n981 292.5
R3839 avss.t132 avss.n987 292.5
R3840 avss.n989 avss.n987 292.5
R3841 avss.t112 avss.n996 292.5
R3842 avss.n996 avss.n376 292.5
R3843 avss.t16 avss.n1017 292.5
R3844 avss.n1017 avss.n1016 292.5
R3845 avss.n1018 avss.t16 292.5
R3846 avss.n1018 avss.n566 292.5
R3847 avss.n1020 avss.t110 292.5
R3848 avss.n1021 avss.n1020 292.5
R3849 avss.t46 avss.n1023 292.5
R3850 avss.n1023 avss.n1022 292.5
R3851 avss.n1033 avss.t181 292.5
R3852 avss.n1034 avss.n1033 292.5
R3853 avss.t181 avss.n1032 292.5
R3854 avss.n1032 avss.n554 292.5
R3855 avss.t46 avss.n559 292.5
R3856 avss.n1028 avss.n559 292.5
R3857 avss.n1011 avss.t110 292.5
R3858 avss.n1011 avss.n560 292.5
R3859 avss.t53 avss.n384 292.5
R3860 avss.n384 avss.n43 292.5
R3861 avss.t115 avss.n1179 292.5
R3862 avss.n1179 avss.n1178 292.5
R3863 avss.n1175 avss.t55 292.5
R3864 avss.n1176 avss.n1175 292.5
R3865 avss.n1187 avss.t111 292.5
R3866 avss.n1188 avss.n1187 292.5
R3867 avss.t106 avss.n1169 292.5
R3868 avss.n1169 avss.n1168 292.5
R3869 avss.n1170 avss.t106 292.5
R3870 avss.n1171 avss.n1170 292.5
R3871 avss.t55 avss.n1174 292.5
R3872 avss.n1174 avss.n1173 292.5
R3873 avss.n1180 avss.t115 292.5
R3874 avss.n1181 avss.n1180 292.5
R3875 avss.t111 avss.n1186 292.5
R3876 avss.n1186 avss.n1185 292.5
R3877 avss.n322 avss.t33 292.5
R3878 avss.n323 avss.n322 292.5
R3879 avss.n307 avss.t78 292.5
R3880 avss.n308 avss.n307 292.5
R3881 avss.t62 avss.n311 292.5
R3882 avss.n311 avss.n310 292.5
R3883 avss.n317 avss.t64 292.5
R3884 avss.n318 avss.n317 292.5
R3885 avss.t33 avss.n321 292.5
R3886 avss.n321 avss.n320 292.5
R3887 avss.t64 avss.n316 292.5
R3888 avss.n316 avss.n315 292.5
R3889 avss.n312 avss.t62 292.5
R3890 avss.n313 avss.n312 292.5
R3891 avss.t78 avss.n306 292.5
R3892 avss.n306 avss.n305 292.5
R3893 avss.n269 avss.t108 292.5
R3894 avss.n271 avss.n269 292.5
R3895 avss.n1251 avss.t168 292.5
R3896 avss.n1252 avss.n1251 292.5
R3897 avss.t60 avss.n1255 292.5
R3898 avss.n1255 avss.n1254 292.5
R3899 avss.n1238 avss.t167 292.5
R3900 avss.n1239 avss.n1238 292.5
R3901 avss.t167 avss.n1237 292.5
R3902 avss.n1237 avss.n1236 292.5
R3903 avss.n1256 avss.t60 292.5
R3904 avss.n1257 avss.n1256 292.5
R3905 avss.t168 avss.n1250 292.5
R3906 avss.n1250 avss.n272 292.5
R3907 avss.n270 avss.t108 292.5
R3908 avss.n1259 avss.n270 292.5
R3909 avss.t104 avss.n1146 292.5
R3910 avss.n1146 avss.n1145 292.5
R3911 avss.n1142 avss.t147 292.5
R3912 avss.n1143 avss.n1142 292.5
R3913 avss.n1133 avss.t151 292.5
R3914 avss.n1133 avss.n1132 292.5
R3915 avss.t53 avss.n383 292.5
R3916 avss.n1123 avss.n383 292.5
R3917 avss.n1139 avss.t151 292.5
R3918 avss.n1139 avss.n1125 292.5
R3919 avss.t147 avss.n1141 292.5
R3920 avss.n1141 avss.n1126 292.5
R3921 avss.n1147 avss.t104 292.5
R3922 avss.n1148 avss.n1147 292.5
R3923 avss.t94 avss.n1062 292.5
R3924 avss.n1062 avss.n1061 292.5
R3925 avss.n1067 avss.t149 292.5
R3926 avss.n1068 avss.n1067 292.5
R3927 avss.t40 avss.n1071 292.5
R3928 avss.n1071 avss.n1070 292.5
R3929 avss.n1052 avss.t30 292.5
R3930 avss.n1053 avss.n1052 292.5
R3931 avss.t30 avss.n1051 292.5
R3932 avss.n1051 avss.n1050 292.5
R3933 avss.n1072 avss.t40 292.5
R3934 avss.n1073 avss.n1072 292.5
R3935 avss.t149 avss.n1066 292.5
R3936 avss.n1066 avss.n1065 292.5
R3937 avss.n1063 avss.t94 292.5
R3938 avss.n1063 avss.n64 292.5
R3939 avss.t96 avss.n1097 292.5
R3940 avss.n1097 avss.n1096 292.5
R3941 avss.n1102 avss.t6 292.5
R3942 avss.n1103 avss.n1102 292.5
R3943 avss.t139 avss.n1106 292.5
R3944 avss.n1106 avss.n1105 292.5
R3945 avss.n388 avss.t114 292.5
R3946 avss.n390 avss.n388 292.5
R3947 avss.n389 avss.t114 292.5
R3948 avss.n1110 avss.n389 292.5
R3949 avss.t139 avss.n1084 292.5
R3950 avss.n1093 avss.n1084 292.5
R3951 avss.t6 avss.n1101 292.5
R3952 avss.n1101 avss.n1100 292.5
R3953 avss.n1098 avss.t96 292.5
R3954 avss.n1099 avss.n1098 292.5
R3955 avss.n456 avss.t90 292.5
R3956 avss.n457 avss.n456 292.5
R3957 avss.t58 avss.n460 292.5
R3958 avss.n460 avss.n459 292.5
R3959 avss.n466 avss.t41 292.5
R3960 avss.n467 avss.n466 292.5
R3961 avss.t32 avss.n470 292.5
R3962 avss.n470 avss.n469 292.5
R3963 avss.n471 avss.t32 292.5
R3964 avss.n472 avss.n471 292.5
R3965 avss.t41 avss.n465 292.5
R3966 avss.n465 avss.n464 292.5
R3967 avss.n461 avss.t58 292.5
R3968 avss.n462 avss.n461 292.5
R3969 avss.t90 avss.n455 292.5
R3970 avss.n455 avss.n454 292.5
R3971 avss.n1272 avss.t88 292.5
R3972 avss.n1273 avss.n1272 292.5
R3973 avss.t0 avss.n1276 292.5
R3974 avss.n1276 avss.n1275 292.5
R3975 avss.n1282 avss.t57 292.5
R3976 avss.n1283 avss.n1282 292.5
R3977 avss.t61 avss.n1286 292.5
R3978 avss.n1286 avss.n1285 292.5
R3979 avss.n1287 avss.t61 292.5
R3980 avss.n1288 avss.n1287 292.5
R3981 avss.t57 avss.n1281 292.5
R3982 avss.n1281 avss.n1280 292.5
R3983 avss.n1277 avss.t0 292.5
R3984 avss.n1278 avss.n1277 292.5
R3985 avss.t88 avss.n1271 292.5
R3986 avss.n1271 avss.n1270 292.5
R3987 avss.t118 avss.n1292 292.5
R3988 avss.n1292 avss.n1291 292.5
R3989 avss.n1293 avss.t118 292.5
R3990 avss.n1294 avss.n1293 292.5
R3991 avss.t124 avss.n392 292.5
R3992 avss.n392 avss.n391 292.5
R3993 avss.n1077 avss.t124 292.5
R3994 avss.n1077 avss.n81 292.5
R3995 avss.n546 avss.t144 292.5
R3996 avss.n547 avss.n546 292.5
R3997 avss.t48 avss.n550 292.5
R3998 avss.n550 avss.n549 292.5
R3999 avss.n538 avss.t166 292.5
R4000 avss.n539 avss.n538 292.5
R4001 avss.t166 avss.n537 292.5
R4002 avss.n537 avss.n536 292.5
R4003 avss.n551 avss.t48 292.5
R4004 avss.n552 avss.n551 292.5
R4005 avss.t144 avss.n545 292.5
R4006 avss.n545 avss.n397 292.5
R4007 avss.t136 avss.n416 292.5
R4008 avss.n480 avss.n416 292.5
R4009 avss.t27 avss.n482 292.5
R4010 avss.n482 avss.n481 292.5
R4011 avss.n478 avss.t158 292.5
R4012 avss.n479 avss.n478 292.5
R4013 avss.t158 avss.n477 292.5
R4014 avss.n477 avss.n476 292.5
R4015 avss.n483 avss.t27 292.5
R4016 avss.n483 avss.n419 292.5
R4017 avss.t136 avss.n485 292.5
R4018 avss.n485 avss.n414 292.5
R4019 avss.n238 avss.t26 292.5
R4020 avss.n238 avss.n217 292.5
R4021 avss.t10 avss.n240 292.5
R4022 avss.n240 avss.n218 292.5
R4023 avss.n214 avss.t2 292.5
R4024 avss.n1296 avss.n214 292.5
R4025 avss.n241 avss.t10 292.5
R4026 avss.n242 avss.n241 292.5
R4027 avss.t26 avss.n237 292.5
R4028 avss.n237 avss.n236 292.5
R4029 avss.n213 avss.t2 292.5
R4030 avss.n215 avss.n213 292.5
R4031 avss.t141 avss.n1359 292.5
R4032 avss.n1359 avss.n140 292.5
R4033 avss.n1357 avss.t142 292.5
R4034 avss.n1357 avss.n139 292.5
R4035 avss.t142 avss.n1356 292.5
R4036 avss.n1356 avss.n1355 292.5
R4037 avss.n1360 avss.t141 292.5
R4038 avss.n1361 avss.n1360 292.5
R4039 avss.t68 avss.n1364 292.5
R4040 avss.n1364 avss.n1363 292.5
R4041 avss.n1365 avss.t68 292.5
R4042 avss.n1366 avss.n1365 292.5
R4043 avss.t156 avss.n1375 292.5
R4044 avss.n1375 avss.n1374 292.5
R4045 avss.n1376 avss.t156 292.5
R4046 avss.n1377 avss.n1376 292.5
R4047 avss.t75 avss.n1380 292.5
R4048 avss.n1380 avss.n1379 292.5
R4049 avss.n1385 avss.t74 292.5
R4050 avss.n1386 avss.n1385 292.5
R4051 avss.t74 avss.n1384 292.5
R4052 avss.n1384 avss.n1383 292.5
R4053 avss.n1381 avss.t75 292.5
R4054 avss.n1382 avss.n1381 292.5
R4055 avss.n1234 avss.n284 251.292
R4056 avss.n954 avss.t130 243.93
R4057 avss.t118 avss.n221 243.93
R4058 avss.n956 avss.n590 240.129
R4059 avss.n993 avss.n378 240.129
R4060 avss.n227 avss.n220 240.129
R4061 avss.n1370 avss.n136 240.129
R4062 avss.n1235 avss.n1234 234.931
R4063 avss.t16 avss.n1010 234.391
R4064 avss.n955 avss.n592 233.124
R4065 avss.n436 avss.n387 231.579
R4066 avss.n576 avss.n575 229.448
R4067 avss.n486 avss.n412 229.448
R4068 avss.n125 avss.n117 229.448
R4069 avss.n1323 avss.t126 227.935
R4070 avss.n1343 avss.t126 227.935
R4071 avss.t124 avss.n386 227.935
R4072 avss.t124 avss.n1076 227.935
R4073 avss.n978 avss.n977 225.304
R4074 avss.t122 avss.n0 225.131
R4075 avss.t128 avss.n379 225.131
R4076 avss.n746 avss.n671 222.845
R4077 avss.n1348 avss.n1347 222.845
R4078 avss.n912 avss.n911 222.845
R4079 avss.n1152 avss.n1120 222.845
R4080 avss.n434 avss.n247 222.845
R4081 avss.n977 avss.t70 219.168
R4082 avss.t135 avss.n412 208.093
R4083 avss.n1010 avss.n1009 203.238
R4084 avss.n1324 avss.n1322 197.293
R4085 avss.n558 avss.n394 197.293
R4086 avss.n1324 avss.n1323 194.755
R4087 avss.n1076 avss.n394 194.755
R4088 avss.t29 avss.n118 191.148
R4089 avss.n1009 avss.n1008 187.16
R4090 avss.n591 avss.n161 180.74
R4091 avss.n1116 avss.n1115 180.74
R4092 avss.n957 avss.n956 178.834
R4093 avss.n378 avss.n364 178.834
R4094 avss.n429 avss.n220 178.834
R4095 avss.n1371 avss.n1370 178.834
R4096 avss.n575 avss.n175 175.339
R4097 avss.n412 avss.n407 175.339
R4098 avss.n438 avss.n437 160.049
R4099 avss.n102 avss.n98 146.25
R4100 avss.t5 avss.n102 146.25
R4101 avss.n113 avss.n110 146.25
R4102 avss.n1394 avss.n110 146.25
R4103 avss.n748 avss.n672 146.25
R4104 avss.n672 avss.t117 146.25
R4105 avss.n671 avss.n670 146.25
R4106 avss.n670 avss.n669 146.25
R4107 avss.n668 avss.n666 146.25
R4108 avss.n4 avss.n668 146.25
R4109 avss.n659 avss.n657 146.25
R4110 avss.n659 avss.t73 146.25
R4111 avss.n772 avss.n771 146.25
R4112 avss.n771 avss.t87 146.25
R4113 avss.n663 avss.n658 146.25
R4114 avss.n664 avss.n663 146.25
R4115 avss.n725 avss.n650 146.25
R4116 avss.n725 avss.t81 146.25
R4117 avss.n744 avss.n743 146.25
R4118 avss.n743 avss.n742 146.25
R4119 avss.n717 avss.n715 146.25
R4120 avss.n717 avss.n52 146.25
R4121 avss.n719 avss.n714 146.25
R4122 avss.n720 avss.n719 146.25
R4123 avss.n724 avss.n722 146.25
R4124 avss.t15 avss.n724 146.25
R4125 avss.n807 avss.n806 146.25
R4126 avss.n806 avss.t93 146.25
R4127 avss.n1349 avss.n1348 146.25
R4128 avss.n1350 avss.n1349 146.25
R4129 avss.n802 avss.n801 146.25
R4130 avss.n803 avss.n802 146.25
R4131 avss.n792 avss.n786 146.25
R4132 avss.n792 avss.n791 146.25
R4133 avss.n794 avss.n778 146.25
R4134 avss.t19 avss.n778 146.25
R4135 avss.n649 avss.n648 146.25
R4136 avss.n648 avss.t83 146.25
R4137 avss.n622 avss.n160 146.25
R4138 avss.n622 avss.n620 146.25
R4139 avss.n624 avss.n623 146.25
R4140 avss.n624 avss.n619 146.25
R4141 avss.n631 avss.n628 146.25
R4142 avss.n631 avss.n630 146.25
R4143 avss.n633 avss.n615 146.25
R4144 avss.t22 avss.n615 146.25
R4145 avss.n847 avss.n846 146.25
R4146 avss.n846 avss.t99 146.25
R4147 avss.n829 avss.n828 146.25
R4148 avss.n828 avss.n827 146.25
R4149 avss.n826 avss.n824 146.25
R4150 avss.n45 avss.n826 146.25
R4151 avss.n821 avss.n816 146.25
R4152 avss.n822 avss.n821 146.25
R4153 avss.n817 avss.n815 146.25
R4154 avss.n817 avss.t39 146.25
R4155 avss.n888 avss.n887 146.25
R4156 avss.n887 avss.t103 146.25
R4157 avss.n909 avss.n908 146.25
R4158 avss.n908 avss.n907 146.25
R4159 avss.n878 avss.n876 146.25
R4160 avss.n878 avss.n20 146.25
R4161 avss.n880 avss.n875 146.25
R4162 avss.n881 avss.n880 146.25
R4163 avss.n893 avss.n885 146.25
R4164 avss.t52 avss.n893 146.25
R4165 avss.n930 avss.n929 146.25
R4166 avss.n929 avss.t101 146.25
R4167 avss.n912 avss.n868 146.25
R4168 avss.n868 avss.n867 146.25
R4169 avss.n866 avss.n864 146.25
R4170 avss.n17 avss.n866 146.25
R4171 avss.n861 avss.n856 146.25
R4172 avss.n862 avss.n861 146.25
R4173 avss.n857 avss.n855 146.25
R4174 avss.n857 avss.t45 146.25
R4175 avss.n954 avss.n953 146.25
R4176 avss.n953 avss.t131 146.25
R4177 avss.n1343 avss.n1342 146.25
R4178 avss.n1342 avss.t127 146.25
R4179 avss.n1323 avss.n166 146.25
R4180 avss.t164 avss.n166 146.25
R4181 avss.n66 avss.n0 146.25
R4182 avss.t123 avss.n66 146.25
R4183 avss.n688 avss.n651 146.25
R4184 avss.n688 avss.t85 146.25
R4185 avss.n707 avss.n706 146.25
R4186 avss.n706 avss.n705 146.25
R4187 avss.n681 avss.n679 146.25
R4188 avss.n681 avss.n7 146.25
R4189 avss.n683 avss.n678 146.25
R4190 avss.n684 avss.n683 146.25
R4191 avss.n692 avss.n686 146.25
R4192 avss.t67 avss.n692 146.25
R4193 avss.n109 avss.n108 146.25
R4194 avss.n111 avss.n109 146.25
R4195 avss.n104 avss.n99 146.25
R4196 avss.n105 avss.n104 146.25
R4197 avss.n118 avss.n116 146.25
R4198 avss.n116 avss.n114 146.25
R4199 avss.n411 avss.n409 146.25
R4200 avss.n409 avss.n408 146.25
R4201 avss.n531 avss.t69 146.25
R4202 avss.n532 avss.n531 146.25
R4203 avss.t69 avss.n60 146.25
R4204 avss.t153 avss.n60 146.25
R4205 avss.t69 avss.n499 146.25
R4206 avss.t152 avss.n499 146.25
R4207 avss.t69 avss.n500 146.25
R4208 avss.n506 avss.n500 146.25
R4209 avss.t69 avss.n530 146.25
R4210 avss.n530 avss.n529 146.25
R4211 avss.n208 avss.n204 146.25
R4212 avss.n204 avss.n203 146.25
R4213 avss.n206 avss.n205 146.25
R4214 avss.n205 avss.n11 146.25
R4215 avss.n1322 avss.n1321 146.25
R4216 avss.n1321 avss.n1320 146.25
R4217 avss.n199 avss.n193 146.25
R4218 avss.n199 avss.n196 146.25
R4219 avss.n1316 avss.n1315 146.25
R4220 avss.t173 avss.n1316 146.25
R4221 avss.n176 avss.n174 146.25
R4222 avss.n176 avss.n170 146.25
R4223 avss.n175 avss.n173 146.25
R4224 avss.n1333 avss.n173 146.25
R4225 avss.n183 avss.n180 146.25
R4226 avss.n183 avss.n182 146.25
R4227 avss.n977 avss.n976 146.25
R4228 avss.n976 avss.n975 146.25
R4229 avss.n934 avss.n610 146.25
R4230 avss.n610 avss.n609 146.25
R4231 avss.n608 avss.n605 146.25
R4232 avss.n15 avss.n608 146.25
R4233 avss.n602 avss.n600 146.25
R4234 avss.n603 avss.n602 146.25
R4235 avss.n949 avss.n590 146.25
R4236 avss.t178 avss.n949 146.25
R4237 avss.n957 avss.n589 146.25
R4238 avss.n958 avss.n589 146.25
R4239 avss.n578 avss.n576 146.25
R4240 avss.n578 avss.n22 146.25
R4241 avss.n587 avss.n585 146.25
R4242 avss.t25 avss.n587 146.25
R4243 avss.n580 avss.n574 146.25
R4244 avss.n581 avss.n580 146.25
R4245 avss.n567 avss.n565 146.25
R4246 avss.n1013 avss.n565 146.25
R4247 avss.n1210 avss.n1209 146.25
R4248 avss.n1209 avss.n1208 146.25
R4249 avss.n1212 avss.n341 146.25
R4250 avss.n1213 avss.n341 146.25
R4251 avss.n1233 avss.n1232 146.25
R4252 avss.n1232 avss.t121 146.25
R4253 avss.n332 avss.n330 146.25
R4254 avss.n332 avss.t138 146.25
R4255 avss.n334 avss.n329 146.25
R4256 avss.n335 avss.n334 146.25
R4257 avss.n1218 avss.n338 146.25
R4258 avss.n1219 avss.n1218 146.25
R4259 avss.n379 avss.n59 146.25
R4260 avss.t129 avss.n59 146.25
R4261 avss.n364 avss.n363 146.25
R4262 avss.n1190 avss.n363 146.25
R4263 avss.n361 avss.n355 146.25
R4264 avss.t134 avss.n361 146.25
R4265 avss.n356 avss.n349 146.25
R4266 avss.n356 avss.n352 146.25
R4267 avss.n1204 avss.n1203 146.25
R4268 avss.n1205 avss.n1204 146.25
R4269 avss.n1008 avss.n1007 146.25
R4270 avss.n1007 avss.n1006 146.25
R4271 avss.n993 avss.n992 146.25
R4272 avss.n992 avss.t113 146.25
R4273 avss.n994 avss.n986 146.25
R4274 avss.n994 avss.n991 146.25
R4275 avss.n1003 avss.n1002 146.25
R4276 avss.n1004 avss.n1003 146.25
R4277 avss.n1010 avss.n564 146.25
R4278 avss.n1014 avss.n564 146.25
R4279 avss.n1030 avss.n557 146.25
R4280 avss.n1030 avss.t47 146.25
R4281 avss.n558 avss.n556 146.25
R4282 avss.n556 avss.n553 146.25
R4283 avss.n1025 avss.n1024 146.25
R4284 avss.n1026 avss.n1025 146.25
R4285 avss.n1153 avss.n1152 146.25
R4286 avss.n1154 avss.n1153 146.25
R4287 avss.n1166 avss.n1164 146.25
R4288 avss.t56 avss.n1166 146.25
R4289 avss.n1167 avss.n267 146.25
R4290 avss.n1167 avss.t107 146.25
R4291 avss.n366 avss.n282 146.25
R4292 avss.n366 avss.n365 146.25
R4293 avss.n288 avss.n284 146.25
R4294 avss.n288 avss.n287 146.25
R4295 avss.n292 avss.n290 146.25
R4296 avss.n293 avss.n292 146.25
R4297 avss.n303 avss.n301 146.25
R4298 avss.t63 avss.n303 146.25
R4299 avss.n304 avss.n268 146.25
R4300 avss.n304 avss.t79 146.25
R4301 avss.n298 avss.n296 146.25
R4302 avss.n299 avss.n298 146.25
R4303 avss.n1235 avss.n281 146.25
R4304 avss.n281 avss.n280 146.25
R4305 avss.n1261 avss.n1260 146.25
R4306 avss.n1260 avss.t109 146.25
R4307 avss.n1248 avss.n1247 146.25
R4308 avss.n1248 avss.t169 146.25
R4309 avss.n1243 avss.n277 146.25
R4310 avss.n1244 avss.n1243 146.25
R4311 avss.n1240 avss.n276 146.25
R4312 avss.n1241 avss.n1240 146.25
R4313 avss.n374 avss.n372 146.25
R4314 avss.n375 avss.n374 146.25
R4315 avss.n1182 avss.n368 146.25
R4316 avss.n1183 avss.n1182 146.25
R4317 avss.n65 avss.n266 146.25
R4318 avss.t105 avss.n65 146.25
R4319 avss.n1129 avss.n1128 146.25
R4320 avss.n1129 avss.t148 146.25
R4321 avss.n1138 avss.n1135 146.25
R4322 avss.n1138 avss.n1137 146.25
R4323 avss.n1151 avss.n1150 146.25
R4324 avss.n1150 avss.n1149 146.25
R4325 avss.n1049 avss.n1048 146.25
R4326 avss.n1048 avss.n1047 146.25
R4327 avss.n63 avss.n265 146.25
R4328 avss.t95 avss.n63 146.25
R4329 avss.n1060 avss.n1059 146.25
R4330 avss.t150 avss.n1060 146.25
R4331 avss.n1055 avss.n1042 146.25
R4332 avss.n1056 avss.n1055 146.25
R4333 avss.n1045 avss.n1041 146.25
R4334 avss.n1046 avss.n1045 146.25
R4335 avss.n1114 avss.n1113 146.25
R4336 avss.n1113 avss.n1112 146.25
R4337 avss.n62 avss.n264 146.25
R4338 avss.t97 avss.n62 146.25
R4339 avss.n1095 avss.n1089 146.25
R4340 avss.t7 avss.n1095 146.25
R4341 avss.n1090 avss.n1083 146.25
R4342 avss.n1090 avss.n1086 146.25
R4343 avss.n1108 avss.n1107 146.25
R4344 avss.n1109 avss.n1108 146.25
R4345 avss.n438 avss.n432 146.25
R4346 avss.n432 avss.n431 146.25
R4347 avss.n453 avss.n263 146.25
R4348 avss.n453 avss.t91 146.25
R4349 avss.n452 avss.n450 146.25
R4350 avss.t59 avss.n452 146.25
R4351 avss.n447 avss.n445 146.25
R4352 avss.n448 avss.n447 146.25
R4353 avss.n441 avss.n439 146.25
R4354 avss.n442 avss.n441 146.25
R4355 avss.n247 avss.n245 146.25
R4356 avss.n245 avss.n244 146.25
R4357 avss.n1269 avss.n262 146.25
R4358 avss.n262 avss.t89 146.25
R4359 avss.n261 avss.n259 146.25
R4360 avss.t1 avss.n261 146.25
R4361 avss.n256 avss.n254 146.25
R4362 avss.n257 avss.n256 146.25
R4363 avss.n250 avss.n248 146.25
R4364 avss.n251 avss.n250 146.25
R4365 avss.n221 avss.n61 146.25
R4366 avss.t119 avss.n61 146.25
R4367 avss.n1078 avss.n386 146.25
R4368 avss.t125 avss.n1078 146.25
R4369 avss.n1076 avss.n1075 146.25
R4370 avss.n1075 avss.t145 146.25
R4371 avss.n407 avss.n406 146.25
R4372 avss.n406 avss.n405 146.25
R4373 avss.n543 avss.n402 146.25
R4374 avss.n544 avss.n543 146.25
R4375 avss.n540 avss.n401 146.25
R4376 avss.n541 avss.n540 146.25
R4377 avss.n426 avss.n420 146.25
R4378 avss.t28 avss.n426 146.25
R4379 avss.n429 avss.n428 146.25
R4380 avss.n474 avss.n428 146.25
R4381 avss.n487 avss.n486 146.25
R4382 avss.n488 avss.n487 146.25
R4383 avss.n417 avss.n415 146.25
R4384 avss.n424 avss.n417 146.25
R4385 avss.n227 avss.n226 146.25
R4386 avss.n226 avss.t11 146.25
R4387 avss.n1299 avss.n1298 146.25
R4388 avss.n1298 avss.n1297 146.25
R4389 avss.n233 avss.n232 146.25
R4390 avss.n233 avss.n216 146.25
R4391 avss.n230 avss.n225 146.25
R4392 avss.n230 avss.n229 146.25
R4393 avss.n155 avss.n136 146.25
R4394 avss.n155 avss.t143 146.25
R4395 avss.n146 avss.n144 146.25
R4396 avss.n144 avss.n142 146.25
R4397 avss.n154 avss.n151 146.25
R4398 avss.n154 avss.n153 146.25
R4399 avss.n147 avss.n145 146.25
R4400 avss.n147 avss.n141 146.25
R4401 avss.n1371 avss.n135 146.25
R4402 avss.n1372 avss.n135 146.25
R4403 avss.n125 avss.n124 146.25
R4404 avss.n124 avss.n120 146.25
R4405 avss.n133 avss.n131 146.25
R4406 avss.t76 avss.n133 146.25
R4407 avss.n127 avss.n123 146.25
R4408 avss.n128 avss.n127 146.25
R4409 avss.n534 avss.n533 144.85
R4410 avss.n1211 avss.n342 140.882
R4411 avss.n956 avss.t130 138.947
R4412 avss.t118 avss.n220 138.947
R4413 avss.n117 avss.n113 129.917
R4414 avss.n1370 avss.t122 128.238
R4415 avss.t128 avss.n378 128.238
R4416 avss.n570 avss.n171 127.745
R4417 avss.n1393 avss.n1392 127.745
R4418 avss.n1207 avss.n340 127.615
R4419 avss.n575 avss.t70 124.843
R4420 avss.t29 avss.n117 108.882
R4421 avss.n1191 avss.n1189 102.794
R4422 avss.n475 avss.n473 102.794
R4423 avss.n871 avss.n588 102.728
R4424 avss.n710 avss.n134 102.728
R4425 avss.n535 avss.n534 84.6865
R4426 avss.t171 avss.n198 78.1731
R4427 avss.n1009 avss.t110 78.1731
R4428 avss.n506 avss.n503 77.9299
R4429 avss.n529 avss.n528 77.9299
R4430 avss.t163 avss.n1324 76.0907
R4431 avss.t144 avss.n394 76.0907
R4432 avss.n759 avss.n4 71.5299
R4433 avss.n703 avss.n7 71.5299
R4434 avss.n684 avss.n675 71.5299
R4435 avss.n1307 avss.n11 71.5299
R4436 avss.n202 avss.n196 71.5299
R4437 avss.n1332 avss.n170 71.5299
R4438 avss.n182 avss.n178 71.5299
R4439 avss.n939 avss.n15 71.5299
R4440 avss.n607 avss.n603 71.5299
R4441 avss.n917 avss.n17 71.5299
R4442 avss.n862 avss.n852 71.5299
R4443 avss.n905 avss.n20 71.5299
R4444 avss.n881 avss.n872 71.5299
R4445 avss.n973 avss.n22 71.5299
R4446 avss.n581 avss.n571 71.5299
R4447 avss.n1015 avss.n1014 71.5299
R4448 avss.n1027 avss.n1026 71.5299
R4449 avss.n1004 avss.n983 71.5299
R4450 avss.n999 avss.n991 71.5299
R4451 avss.n1205 avss.n346 71.5299
R4452 avss.n1200 avss.n352 71.5299
R4453 avss.n1219 avss.n336 71.5299
R4454 avss.n1224 avss.n335 71.5299
R4455 avss.n319 avss.n293 71.5299
R4456 avss.n299 avss.n294 71.5299
R4457 avss.n1242 avss.n1241 71.5299
R4458 avss.n1253 avss.n1244 71.5299
R4459 avss.n542 avss.n541 71.5299
R4460 avss.n548 avss.n544 71.5299
R4461 avss.n489 avss.n488 71.5299
R4462 avss.n424 avss.n423 71.5299
R4463 avss.n468 avss.n442 71.5299
R4464 avss.n448 avss.n443 71.5299
R4465 avss.n235 avss.n216 71.5299
R4466 avss.n229 avss.n223 71.5299
R4467 avss.n1284 avss.n251 71.5299
R4468 avss.n257 avss.n252 71.5299
R4469 avss.n1109 avss.n1080 71.5299
R4470 avss.n1104 avss.n1086 71.5299
R4471 avss.n1054 avss.n1046 71.5299
R4472 avss.n1069 avss.n1056 71.5299
R4473 avss.n1149 avss.n1124 71.5299
R4474 avss.n1137 avss.n1131 71.5299
R4475 avss.n1184 avss.n1183 71.5299
R4476 avss.n375 avss.n370 71.5299
R4477 avss.n834 avss.n45 71.5299
R4478 avss.n822 avss.n812 71.5299
R4479 avss.n641 avss.n619 71.5299
R4480 avss.n630 avss.n626 71.5299
R4481 avss.n803 avss.n783 71.5299
R4482 avss.n791 avss.n790 71.5299
R4483 avss.n153 avss.n149 71.5299
R4484 avss.n1362 avss.n141 71.5299
R4485 avss.n740 avss.n52 71.5299
R4486 avss.n720 avss.n711 71.5299
R4487 avss.n1387 avss.n120 71.5299
R4488 avss.n128 avss.n121 71.5299
R4489 avss.n111 avss.n106 71.5299
R4490 avss.n1403 avss.n105 71.5299
R4491 avss.n664 avss.n654 71.5299
R4492 avss.n6 avss.n4 70.024
R4493 avss.n10 avss.n7 70.024
R4494 avss.n698 avss.n684 70.024
R4495 avss.n13 avss.n11 70.024
R4496 avss.n1312 avss.n196 70.024
R4497 avss.n14 avss.n170 70.024
R4498 avss.n182 avss.n181 70.024
R4499 avss.n16 avss.n15 70.024
R4500 avss.n944 avss.n603 70.024
R4501 avss.n19 avss.n17 70.024
R4502 avss.n922 avss.n862 70.024
R4503 avss.n21 avss.n20 70.024
R4504 avss.n882 avss.n881 70.024
R4505 avss.n23 avss.n22 70.024
R4506 avss.n582 avss.n581 70.024
R4507 avss.n1014 avss.n24 70.024
R4508 avss.n1026 avss.n561 70.024
R4509 avss.n25 avss.n1004 70.024
R4510 avss.n991 avss.n990 70.024
R4511 avss.n27 avss.n1205 70.024
R4512 avss.n360 avss.n352 70.024
R4513 avss.n29 avss.n1219 70.024
R4514 avss.n335 avss.n326 70.024
R4515 avss.n293 avss.n30 70.024
R4516 avss.n314 avss.n299 70.024
R4517 avss.n1241 avss.n31 70.024
R4518 avss.n1244 avss.n273 70.024
R4519 avss.n541 avss.n32 70.024
R4520 avss.n544 avss.n398 70.024
R4521 avss.n509 avss.n506 70.024
R4522 avss.n529 avss.n35 70.024
R4523 avss.n488 avss.n36 70.024
R4524 avss.n425 avss.n424 70.024
R4525 avss.n442 avss.n38 70.024
R4526 avss.n463 avss.n448 70.024
R4527 avss.n39 avss.n216 70.024
R4528 avss.n229 avss.n228 70.024
R4529 avss.n251 avss.n40 70.024
R4530 avss.n1279 avss.n257 70.024
R4531 avss.n41 avss.n1109 70.024
R4532 avss.n1094 avss.n1086 70.024
R4533 avss.n1046 avss.n42 70.024
R4534 avss.n1056 avss.n1038 70.024
R4535 avss.n1149 avss.n44 70.024
R4536 avss.n1137 avss.n1136 70.024
R4537 avss.n1183 avss.n26 70.024
R4538 avss.n1177 avss.n375 70.024
R4539 avss.n47 avss.n45 70.024
R4540 avss.n839 avss.n822 70.024
R4541 avss.n48 avss.n619 70.024
R4542 avss.n630 avss.n629 70.024
R4543 avss.n50 avss.n803 70.024
R4544 avss.n791 avss.n788 70.024
R4545 avss.n153 avss.n152 70.024
R4546 avss.n51 avss.n141 70.024
R4547 avss.n54 avss.n52 70.024
R4548 avss.n734 avss.n720 70.024
R4549 avss.n120 avss.n55 70.024
R4550 avss.n129 avss.n128 70.024
R4551 avss.n3 avss.n111 70.024
R4552 avss.n105 avss.n95 70.024
R4553 avss.n764 avss.n664 70.024
R4554 avss.n188 avss.n157 69.7769
R4555 avss.n1037 avss.n382 69.7113
R4556 avss.n758 avss.n669 66.6012
R4557 avss.n705 avss.n704 66.6012
R4558 avss.n916 avss.n867 66.6012
R4559 avss.n938 avss.n609 66.6012
R4560 avss.n907 avss.n906 66.6012
R4561 avss.n975 avss.n974 66.6012
R4562 avss.n1334 avss.n1333 66.6012
R4563 avss.n1016 avss.n1013 66.6012
R4564 avss.n1006 avss.n982 66.6012
R4565 avss.n1208 avss.n345 66.6012
R4566 avss.n1214 avss.n1213 66.6012
R4567 avss.n320 avss.n287 66.6012
R4568 avss.n1239 avss.n280 66.6012
R4569 avss.n539 avss.n405 66.6012
R4570 avss.n532 avss.n495 66.6012
R4571 avss.n1306 avss.n203 66.6012
R4572 avss.n490 avss.n408 66.6012
R4573 avss.n469 avss.n431 66.6012
R4574 avss.n1297 avss.n215 66.6012
R4575 avss.n1285 avss.n244 66.6012
R4576 avss.n1112 avss.n390 66.6012
R4577 avss.n1053 avss.n1047 66.6012
R4578 avss.n1185 avss.n365 66.6012
R4579 avss.n833 avss.n827 66.6012
R4580 avss.n642 avss.n620 66.6012
R4581 avss.n1363 avss.n142 66.6012
R4582 avss.n742 avss.n741 66.6012
R4583 avss.n1388 avss.n114 66.6012
R4584 avss.n1395 avss.n1394 66.6012
R4585 avss.t87 avss.n770 66.3309
R4586 avss.t85 avss.n58 66.3309
R4587 avss.t101 avss.n928 66.3309
R4588 avss.n892 avss.t103 66.3309
R4589 avss.t109 avss.n271 66.3309
R4590 avss.n521 avss.t153 66.3309
R4591 avss.n457 avss.t91 66.3309
R4592 avss.n1273 avss.t89 66.3309
R4593 avss.n1096 avss.t97 66.3309
R4594 avss.n1061 avss.t95 66.3309
R4595 avss.n1145 avss.t105 66.3309
R4596 avss.n1171 avss.t107 66.3309
R4597 avss.n308 avss.t79 66.3309
R4598 avss.t99 avss.n845 66.3309
R4599 avss.t83 avss.n647 66.3309
R4600 avss.t93 avss.n805 66.3309
R4601 avss.t81 avss.n67 66.3309
R4602 avss.n514 avss.t152 64.3949
R4603 avss.n522 avss.t152 63.624
R4604 avss.n759 avss.n758 59.4829
R4605 avss.n760 avss.n759 59.4829
R4606 avss.n760 avss.n654 59.4829
R4607 avss.n768 avss.n654 59.4829
R4608 avss.n769 avss.n768 59.4829
R4609 avss.n770 avss.n769 59.4829
R4610 avss.n704 avss.n703 59.4829
R4611 avss.n703 avss.n702 59.4829
R4612 avss.n702 avss.n675 59.4829
R4613 avss.n694 avss.n675 59.4829
R4614 avss.n694 avss.n693 59.4829
R4615 avss.n693 avss.n58 59.4829
R4616 avss.n1307 avss.n1306 59.4829
R4617 avss.n1308 avss.n1307 59.4829
R4618 avss.n1308 avss.n202 59.4829
R4619 avss.n202 avss.n189 59.4829
R4620 avss.n1317 avss.n189 59.4829
R4621 avss.n1318 avss.n1317 59.4829
R4622 avss.n1334 avss.n1332 59.4829
R4623 avss.n1332 avss.n1331 59.4829
R4624 avss.n1331 avss.n178 59.4829
R4625 avss.n178 avss.n165 59.4829
R4626 avss.n1339 avss.n165 59.4829
R4627 avss.n1340 avss.n1339 59.4829
R4628 avss.n939 avss.n938 59.4829
R4629 avss.n940 avss.n939 59.4829
R4630 avss.n940 avss.n607 59.4829
R4631 avss.n607 avss.n596 59.4829
R4632 avss.n950 avss.n596 59.4829
R4633 avss.n951 avss.n950 59.4829
R4634 avss.n917 avss.n916 59.4829
R4635 avss.n918 avss.n917 59.4829
R4636 avss.n918 avss.n852 59.4829
R4637 avss.n926 avss.n852 59.4829
R4638 avss.n927 avss.n926 59.4829
R4639 avss.n928 avss.n927 59.4829
R4640 avss.n906 avss.n905 59.4829
R4641 avss.n905 avss.n904 59.4829
R4642 avss.n904 avss.n872 59.4829
R4643 avss.n895 avss.n872 59.4829
R4644 avss.n895 avss.n894 59.4829
R4645 avss.n894 avss.n892 59.4829
R4646 avss.n974 avss.n973 59.4829
R4647 avss.n973 avss.n972 59.4829
R4648 avss.n972 avss.n571 59.4829
R4649 avss.n965 avss.n571 59.4829
R4650 avss.n965 avss.n964 59.4829
R4651 avss.n964 avss.n963 59.4829
R4652 avss.n1029 avss.n554 59.4829
R4653 avss.n1029 avss.n1028 59.4829
R4654 avss.n1028 avss.n1027 59.4829
R4655 avss.n1027 avss.n560 59.4829
R4656 avss.n1015 avss.n560 59.4829
R4657 avss.n1016 avss.n1015 59.4829
R4658 avss.n1157 avss.n381 59.4829
R4659 avss.n998 avss.n381 59.4829
R4660 avss.n999 avss.n998 59.4829
R4661 avss.n1000 avss.n999 59.4829
R4662 avss.n1000 avss.n983 59.4829
R4663 avss.n983 avss.n982 59.4829
R4664 avss.n1192 avss.n353 59.4829
R4665 avss.n1199 avss.n353 59.4829
R4666 avss.n1200 avss.n1199 59.4829
R4667 avss.n1201 avss.n1200 59.4829
R4668 avss.n1201 avss.n346 59.4829
R4669 avss.n346 avss.n345 59.4829
R4670 avss.n1226 avss.n1225 59.4829
R4671 avss.n1227 avss.n1226 59.4829
R4672 avss.n1227 avss.n1224 59.4829
R4673 avss.n1224 avss.n1223 59.4829
R4674 avss.n1223 avss.n336 59.4829
R4675 avss.n1214 avss.n336 59.4829
R4676 avss.n309 avss.n308 59.4829
R4677 avss.n310 avss.n309 59.4829
R4678 avss.n310 avss.n294 59.4829
R4679 avss.n318 avss.n294 59.4829
R4680 avss.n319 avss.n318 59.4829
R4681 avss.n320 avss.n319 59.4829
R4682 avss.n1245 avss.n271 59.4829
R4683 avss.n1252 avss.n1245 59.4829
R4684 avss.n1253 avss.n1252 59.4829
R4685 avss.n1254 avss.n1253 59.4829
R4686 avss.n1254 avss.n1242 59.4829
R4687 avss.n1242 avss.n1239 59.4829
R4688 avss.n396 avss.n391 59.4829
R4689 avss.n547 avss.n396 59.4829
R4690 avss.n548 avss.n547 59.4829
R4691 avss.n549 avss.n548 59.4829
R4692 avss.n549 avss.n542 59.4829
R4693 avss.n542 avss.n539 59.4829
R4694 avss.n476 avss.n430 59.4829
R4695 avss.n430 avss.n419 59.4829
R4696 avss.n423 avss.n419 59.4829
R4697 avss.n423 avss.n414 59.4829
R4698 avss.n489 avss.n414 59.4829
R4699 avss.n490 avss.n489 59.4829
R4700 avss.n458 avss.n457 59.4829
R4701 avss.n459 avss.n458 59.4829
R4702 avss.n459 avss.n443 59.4829
R4703 avss.n467 avss.n443 59.4829
R4704 avss.n468 avss.n467 59.4829
R4705 avss.n469 avss.n468 59.4829
R4706 avss.n1291 avss.n243 59.4829
R4707 avss.n243 avss.n242 59.4829
R4708 avss.n242 avss.n223 59.4829
R4709 avss.n236 avss.n223 59.4829
R4710 avss.n236 avss.n235 59.4829
R4711 avss.n235 avss.n215 59.4829
R4712 avss.n1274 avss.n1273 59.4829
R4713 avss.n1275 avss.n1274 59.4829
R4714 avss.n1275 avss.n252 59.4829
R4715 avss.n1283 avss.n252 59.4829
R4716 avss.n1284 avss.n1283 59.4829
R4717 avss.n1285 avss.n1284 59.4829
R4718 avss.n1096 avss.n1087 59.4829
R4719 avss.n1103 avss.n1087 59.4829
R4720 avss.n1104 avss.n1103 59.4829
R4721 avss.n1105 avss.n1104 59.4829
R4722 avss.n1105 avss.n1080 59.4829
R4723 avss.n1080 avss.n390 59.4829
R4724 avss.n1061 avss.n1057 59.4829
R4725 avss.n1068 avss.n1057 59.4829
R4726 avss.n1069 avss.n1068 59.4829
R4727 avss.n1070 avss.n1069 59.4829
R4728 avss.n1070 avss.n1054 59.4829
R4729 avss.n1054 avss.n1053 59.4829
R4730 avss.n1145 avss.n1144 59.4829
R4731 avss.n1144 avss.n1143 59.4829
R4732 avss.n1143 avss.n1131 59.4829
R4733 avss.n1132 avss.n1131 59.4829
R4734 avss.n1132 avss.n1124 59.4829
R4735 avss.n1124 avss.n1123 59.4829
R4736 avss.n1172 avss.n1171 59.4829
R4737 avss.n1173 avss.n1172 59.4829
R4738 avss.n1173 avss.n370 59.4829
R4739 avss.n1181 avss.n370 59.4829
R4740 avss.n1184 avss.n1181 59.4829
R4741 avss.n1185 avss.n1184 59.4829
R4742 avss.n834 avss.n833 59.4829
R4743 avss.n835 avss.n834 59.4829
R4744 avss.n835 avss.n812 59.4829
R4745 avss.n843 avss.n812 59.4829
R4746 avss.n844 avss.n843 59.4829
R4747 avss.n845 avss.n844 59.4829
R4748 avss.n642 avss.n641 59.4829
R4749 avss.n641 avss.n640 59.4829
R4750 avss.n640 avss.n626 59.4829
R4751 avss.n626 avss.n614 59.4829
R4752 avss.n646 avss.n614 59.4829
R4753 avss.n647 avss.n646 59.4829
R4754 avss.n783 avss.n782 59.4829
R4755 avss.n789 avss.n783 59.4829
R4756 avss.n790 avss.n789 59.4829
R4757 avss.n790 avss.n777 59.4829
R4758 avss.n804 avss.n777 59.4829
R4759 avss.n805 avss.n804 59.4829
R4760 avss.n1363 avss.n1362 59.4829
R4761 avss.n1362 avss.n1361 59.4829
R4762 avss.n1361 avss.n149 59.4829
R4763 avss.n1355 avss.n149 59.4829
R4764 avss.n1355 avss.n1354 59.4829
R4765 avss.n1354 avss.n1353 59.4829
R4766 avss.n741 avss.n740 59.4829
R4767 avss.n740 avss.n739 59.4829
R4768 avss.n739 avss.n711 59.4829
R4769 avss.n730 avss.n711 59.4829
R4770 avss.n730 avss.n729 59.4829
R4771 avss.n729 avss.n67 59.4829
R4772 avss.n1388 avss.n1387 59.4829
R4773 avss.n1387 avss.n1386 59.4829
R4774 avss.n1386 avss.n121 59.4829
R4775 avss.n1379 avss.n121 59.4829
R4776 avss.n1379 avss.n1378 59.4829
R4777 avss.n1378 avss.n1377 59.4829
R4778 avss.n1395 avss.n106 59.4829
R4779 avss.n1402 avss.n106 59.4829
R4780 avss.n1403 avss.n1402 59.4829
R4781 avss.n1404 avss.n1403 59.4829
R4782 avss.n1404 avss.n103 59.4829
R4783 avss.n752 avss.n103 59.4829
R4784 avss.n1157 avss.n1156 58.5229
R4785 avss.n1225 avss.n325 58.5229
R4786 avss.n1291 avss.n1290 58.5229
R4787 avss.n1079 avss.n391 58.5229
R4788 avss.n952 avss.n951 58.4589
R4789 avss.n1341 avss.n1340 58.4589
R4790 avss.n1353 avss.n1352 58.4589
R4791 avss.n753 avss.n752 58.4589
R4792 avss.n693 avss.t67 57.224
R4793 avss.n1317 avss.t173 57.224
R4794 avss.n1339 avss.t164 57.224
R4795 avss.n950 avss.t178 57.224
R4796 avss.n927 avss.t45 57.224
R4797 avss.n894 avss.t52 57.224
R4798 avss.n964 avss.t25 57.224
R4799 avss.t47 avss.n1029 57.224
R4800 avss.n381 avss.t113 57.224
R4801 avss.t134 avss.n353 57.224
R4802 avss.n1226 avss.t138 57.224
R4803 avss.n1245 avss.t169 57.224
R4804 avss.t145 avss.n396 57.224
R4805 avss.n430 avss.t28 57.224
R4806 avss.n458 avss.t59 57.224
R4807 avss.n243 avss.t11 57.224
R4808 avss.n1274 avss.t1 57.224
R4809 avss.t7 avss.n1087 57.224
R4810 avss.t150 avss.n1057 57.224
R4811 avss.n1144 avss.t148 57.224
R4812 avss.n1172 avss.t56 57.224
R4813 avss.n309 avss.t63 57.224
R4814 avss.n844 avss.t39 57.224
R4815 avss.n646 avss.t22 57.224
R4816 avss.n804 avss.t19 57.224
R4817 avss.n1354 avss.t143 57.224
R4818 avss.n729 avss.t15 57.224
R4819 avss.n1378 avss.t76 57.224
R4820 avss.n103 avss.t5 57.224
R4821 avss.n769 avss.t73 57.224
R4822 avss.n1123 avss.n382 57.2017
R4823 avss.n782 avss.n157 57.1507
R4824 avss.n1319 avss.t180 56.3205
R4825 avss.t155 avss.n588 56.3205
R4826 avss.t157 avss.n134 56.3205
R4827 avss.n1036 avss.t182 53.7605
R4828 avss.n1191 avss.t161 53.7605
R4829 avss.n475 avss.t159 53.7605
R4830 avss.n522 avss.n521 53.0829
R4831 avss.n523 avss.n522 53.0829
R4832 avss.n523 avss.n503 53.0829
R4833 avss.n527 avss.n503 53.0829
R4834 avss.n528 avss.n527 53.0829
R4835 avss.n528 avss.n495 53.0829
R4836 avss.t5 avss.n68 51.577
R4837 avss.n5 avss.t73 51.577
R4838 avss.t67 avss.n69 51.577
R4839 avss.t173 avss.n12 51.577
R4840 avss.t164 avss.n70 51.577
R4841 avss.t178 avss.n71 51.577
R4842 avss.n18 avss.t45 51.577
R4843 avss.t52 avss.n72 51.577
R4844 avss.t25 avss.n73 51.577
R4845 avss.t47 avss.n74 51.577
R4846 avss.n75 avss.t113 51.577
R4847 avss.n76 avss.t56 51.577
R4848 avss.n77 avss.t134 51.577
R4849 avss.n78 avss.t138 51.577
R4850 avss.n79 avss.t63 51.577
R4851 avss.n80 avss.t169 51.577
R4852 avss.t145 avss.n82 51.577
R4853 avss.n83 avss.t28 51.577
R4854 avss.n84 avss.t59 51.577
R4855 avss.n85 avss.t11 51.577
R4856 avss.n86 avss.t1 51.577
R4857 avss.n87 avss.t7 51.577
R4858 avss.n88 avss.t150 51.577
R4859 avss.n89 avss.t148 51.577
R4860 avss.n46 avss.t39 51.577
R4861 avss.t22 avss.n90 51.577
R4862 avss.t19 avss.n91 51.577
R4863 avss.n92 avss.t143 51.577
R4864 avss.t15 avss.n93 51.577
R4865 avss.t76 avss.n94 51.577
R4866 avss.n1037 avss.n1036 49.6908
R4867 avss.n1319 avss.n188 49.6251
R4868 avss.n754 avss.n753 47.0085
R4869 avss.n952 avss.n595 47.0085
R4870 avss.n325 avss.n324 47.0085
R4871 avss.n1290 avss.n1289 47.0085
R4872 avss.n1111 avss.n1079 47.0085
R4873 avss.n1341 avss.n164 47.0085
R4874 avss.n1352 avss.n1351 47.0085
R4875 avss.n1156 avss.n1155 47.0085
R4876 avss.n1302 avss.n1301 34.8028
R4877 avss.n534 avss.n494 30.0641
R4878 avss.n305 avss.t79 27.3476
R4879 avss.n1168 avss.t107 27.3476
R4880 avss.n1148 avss.t105 27.3476
R4881 avss.t95 avss.n64 27.3476
R4882 avss.n1099 avss.t97 27.3476
R4883 avss.n1270 avss.t89 27.3476
R4884 avss.n454 avss.t91 27.3476
R4885 avss.t109 avss.n1259 27.3476
R4886 avss.n728 avss.t81 27.3158
R4887 avss.n779 avss.t93 27.3158
R4888 avss.n616 avss.t83 27.3158
R4889 avss.n820 avss.t99 27.3158
R4890 avss.t153 avss.n519 27.3158
R4891 avss.n889 avss.t103 27.3158
R4892 avss.n860 avss.t101 27.3158
R4893 avss.n691 avss.t85 27.3158
R4894 avss.n662 avss.t87 27.3158
R4895 avss.n705 avss.n8 27.2827
R4896 avss.n935 avss.n609 27.2827
R4897 avss.n1013 avss.n566 27.2827
R4898 avss.n1006 avss.n1005 27.2827
R4899 avss.n1236 avss.n280 27.2827
R4900 avss.n1297 avss.n1296 27.2827
R4901 avss.n1050 avss.n1047 27.2827
R4902 avss.n645 avss.n620 27.2827
R4903 avss.n1366 avss.n142 27.2827
R4904 avss.n1160 avss.t129 27.1556
R4905 avss.t121 avss.n1231 27.1556
R4906 avss.n1294 avss.t119 27.1556
R4907 avss.n81 avss.t125 27.1556
R4908 avss.n749 avss.t117 27.1238
R4909 avss.n597 avss.t131 27.1238
R4910 avss.n167 avss.t127 27.1238
R4911 avss.n1368 avss.t123 27.1238
R4912 avss.n514 avss.n513 20.6118
R4913 avss.n1189 avss.n365 19.7162
R4914 avss.n473 avss.n431 19.7162
R4915 avss.n907 avss.n871 19.6531
R4916 avss.n742 avss.n710 19.6531
R4917 avss.n1320 avss.n187 18.9639
R4918 avss.n959 avss.n958 18.9639
R4919 avss.n1373 avss.n1372 18.9639
R4920 avss.n1035 avss.n553 18.8378
R4921 avss.n1190 avss.n362 18.8378
R4922 avss.n474 avss.n427 18.8378
R4923 avss.n513 avss.n203 18.1556
R4924 avss.n755 avss.n754 15.0705
R4925 avss.n913 avss.n595 15.0705
R4926 avss.n583 avss.n570 15.0705
R4927 avss.n1337 avss.n171 15.0705
R4928 avss.n1155 avss.n43 15.0705
R4929 avss.n1207 avss.n1206 15.0705
R4930 avss.n1217 avss.n340 15.0705
R4931 avss.n324 avss.n323 15.0705
R4932 avss.n536 avss.n535 15.0705
R4933 avss.n494 avss.n493 15.0705
R4934 avss.n1289 avss.n1288 15.0705
R4935 avss.n1111 avss.n1110 15.0705
R4936 avss.n830 avss.n164 15.0705
R4937 avss.n1351 avss.n49 15.0705
R4938 avss.n1392 avss.n1391 15.0705
R4939 avss.n1393 avss.n112 15.0705
R4940 avss.n533 avss.n532 14.7597
R4941 avss.n533 avss.n33 12.9401
R4942 avss.n754 avss.n669 12.2127
R4943 avss.n867 avss.n595 12.2127
R4944 avss.n975 avss.n570 12.2127
R4945 avss.n1333 avss.n171 12.2127
R4946 avss.n1155 avss.n1154 12.2127
R4947 avss.n1208 avss.n1207 12.2127
R4948 avss.n1213 avss.n340 12.2127
R4949 avss.n324 avss.n287 12.2127
R4950 avss.n535 avss.n405 12.2127
R4951 avss.n494 avss.n408 12.2127
R4952 avss.n1289 avss.n244 12.2127
R4953 avss.n1112 avss.n1111 12.2127
R4954 avss.n827 avss.n164 12.2127
R4955 avss.n1351 avss.n1350 12.2127
R4956 avss.n1392 avss.n114 12.2127
R4957 avss.n1394 avss.n1393 12.2127
R4958 avss.n519 avss.n34 10.1498
R4959 avss.n749 avss.n68 10.0231
R4960 avss.n5 avss.n662 10.0231
R4961 avss.n69 avss.n691 10.0231
R4962 avss.n12 avss.n190 10.0231
R4963 avss.n71 avss.n597 10.0231
R4964 avss.n18 avss.n860 10.0231
R4965 avss.n889 avss.n72 10.0231
R4966 avss.n960 avss.n73 10.0231
R4967 avss.n75 avss.n1160 10.0231
R4968 avss.n1231 avss.n78 10.0231
R4969 avss.n1259 avss.n80 10.0231
R4970 avss.n454 avss.n84 10.0231
R4971 avss.n85 avss.n1294 10.0231
R4972 avss.n1270 avss.n86 10.0231
R4973 avss.n83 avss.n479 10.0231
R4974 avss.n82 avss.n81 10.0231
R4975 avss.n87 avss.n1099 10.0231
R4976 avss.n64 avss.n88 10.0231
R4977 avss.n89 avss.n1148 10.0231
R4978 avss.n1168 avss.n76 10.0231
R4979 avss.n305 avss.n79 10.0231
R4980 avss.n77 avss.n1195 10.0231
R4981 avss.n1034 avss.n74 10.0231
R4982 avss.n70 avss.n167 10.0231
R4983 avss.n46 avss.n820 10.0231
R4984 avss.n90 avss.n616 10.0231
R4985 avss.n91 avss.n779 10.0231
R4986 avss.n1368 avss.n92 10.0231
R4987 avss.n93 avss.n728 10.0231
R4988 avss.n1374 avss.n94 10.0231
R4989 avss.n1399 avss.n95 10.0124
R4990 avss.n1407 avss.n95 10.0124
R4991 avss.n764 avss.n763 10.0124
R4992 avss.n765 avss.n764 10.0124
R4993 avss.n699 avss.n698 10.0124
R4994 avss.n698 avss.n697 10.0124
R4995 avss.n1312 avss.n1311 10.0124
R4996 avss.n1313 avss.n1312 10.0124
R4997 avss.n181 avss.n169 10.0124
R4998 avss.n181 avss.n168 10.0124
R4999 avss.n944 avss.n943 10.0124
R5000 avss.n945 avss.n944 10.0124
R5001 avss.n922 avss.n921 10.0124
R5002 avss.n923 avss.n922 10.0124
R5003 avss.n901 avss.n882 10.0124
R5004 avss.n898 avss.n882 10.0124
R5005 avss.n969 avss.n582 10.0124
R5006 avss.n968 avss.n582 10.0124
R5007 avss.n1022 avss.n561 10.0124
R5008 avss.n1021 avss.n561 10.0124
R5009 avss.n990 avss.n376 10.0124
R5010 avss.n990 avss.n989 10.0124
R5011 avss.n1177 avss.n1176 10.0124
R5012 avss.n1178 avss.n1177 10.0124
R5013 avss.n1196 avss.n360 10.0124
R5014 avss.n360 avss.n359 10.0124
R5015 avss.n1230 avss.n326 10.0124
R5016 avss.n1220 avss.n326 10.0124
R5017 avss.n314 avss.n313 10.0124
R5018 avss.n315 avss.n314 10.0124
R5019 avss.n273 avss.n272 10.0124
R5020 avss.n1257 avss.n273 10.0124
R5021 avss.n398 avss.n397 10.0124
R5022 avss.n552 avss.n398 10.0124
R5023 avss.n515 avss.n509 10.0124
R5024 avss.n509 avss.n508 10.0124
R5025 avss.n481 avss.n425 10.0124
R5026 avss.n480 avss.n425 10.0124
R5027 avss.n463 avss.n462 10.0124
R5028 avss.n464 avss.n463 10.0124
R5029 avss.n228 avss.n218 10.0124
R5030 avss.n228 avss.n217 10.0124
R5031 avss.n1279 avss.n1278 10.0124
R5032 avss.n1280 avss.n1279 10.0124
R5033 avss.n1100 avss.n1094 10.0124
R5034 avss.n1094 avss.n1093 10.0124
R5035 avss.n1065 avss.n1038 10.0124
R5036 avss.n1073 avss.n1038 10.0124
R5037 avss.n1136 avss.n1126 10.0124
R5038 avss.n1136 avss.n1125 10.0124
R5039 avss.n839 avss.n838 10.0124
R5040 avss.n840 avss.n839 10.0124
R5041 avss.n629 avss.n618 10.0124
R5042 avss.n629 avss.n617 10.0124
R5043 avss.n788 avss.n781 10.0124
R5044 avss.n788 avss.n780 10.0124
R5045 avss.n152 avss.n140 10.0124
R5046 avss.n152 avss.n139 10.0124
R5047 avss.n736 avss.n734 10.0124
R5048 avss.n734 avss.n733 10.0124
R5049 avss.n1383 avss.n129 10.0124
R5050 avss.n1382 avss.n129 10.0124
R5051 avss.n323 avss.n30 9.98215
R5052 avss.n1288 avss.n40 9.98215
R5053 avss.n1110 avss.n41 9.98215
R5054 avss.n44 avss.n43 9.98215
R5055 avss.n10 avss.n8 9.97283
R5056 avss.n913 avss.n19 9.97283
R5057 avss.n935 avss.n16 9.97283
R5058 avss.n23 avss.n583 9.97283
R5059 avss.n14 avss.n1337 9.97283
R5060 avss.n21 avss.n883 9.97283
R5061 avss.n566 avss.n24 9.97283
R5062 avss.n1005 avss.n25 9.97283
R5063 avss.n1206 avss.n27 9.97283
R5064 avss.n29 avss.n1217 9.97283
R5065 avss.n1236 avss.n31 9.97283
R5066 avss.n35 avss.n33 9.97283
R5067 avss.n512 avss.n13 9.97283
R5068 avss.n493 avss.n36 9.97283
R5069 avss.n472 avss.n38 9.97283
R5070 avss.n1296 avss.n39 9.97283
R5071 avss.n536 avss.n32 9.97283
R5072 avss.n1050 avss.n42 9.97283
R5073 avss.n1188 avss.n26 9.97283
R5074 avss.n830 avss.n47 9.97283
R5075 avss.n48 avss.n645 9.97283
R5076 avss.n50 avss.n49 9.97283
R5077 avss.n51 avss.n1366 9.97283
R5078 avss.n1391 avss.n55 9.97283
R5079 avss.n112 avss.n3 9.97283
R5080 avss.n54 avss.n735 9.97283
R5081 avss.n755 avss.n6 9.97283
R5082 avss.n68 avss.n1407 9.88565
R5083 avss.n765 avss.n5 9.88565
R5084 avss.n697 avss.n69 9.88565
R5085 avss.n1313 avss.n12 9.88565
R5086 avss.n70 avss.n168 9.88565
R5087 avss.n945 avss.n71 9.88565
R5088 avss.n923 avss.n18 9.88565
R5089 avss.n72 avss.n898 9.88565
R5090 avss.n73 avss.n968 9.88565
R5091 avss.n1022 avss.n74 9.88565
R5092 avss.n75 avss.n376 9.88565
R5093 avss.n1176 avss.n76 9.88565
R5094 avss.n1196 avss.n77 9.88565
R5095 avss.n78 avss.n1230 9.88565
R5096 avss.n313 avss.n79 9.88565
R5097 avss.n80 avss.n272 9.88565
R5098 avss.n82 avss.n397 9.88565
R5099 avss.n481 avss.n83 9.88565
R5100 avss.n462 avss.n84 9.88565
R5101 avss.n85 avss.n218 9.88565
R5102 avss.n1278 avss.n86 9.88565
R5103 avss.n1100 avss.n87 9.88565
R5104 avss.n1065 avss.n88 9.88565
R5105 avss.n89 avss.n1126 9.88565
R5106 avss.n840 avss.n46 9.88565
R5107 avss.n90 avss.n617 9.88565
R5108 avss.n91 avss.n780 9.88565
R5109 avss.n92 avss.n139 9.88565
R5110 avss.n733 avss.n93 9.88565
R5111 avss.n94 avss.n1382 9.88565
R5112 avss.n513 avss.n512 9.5442
R5113 avss.n1399 avss.n3 9.44208
R5114 avss.n763 avss.n6 9.44208
R5115 avss.n699 avss.n10 9.44208
R5116 avss.n1311 avss.n13 9.44208
R5117 avss.n14 avss.n169 9.44208
R5118 avss.n943 avss.n16 9.44208
R5119 avss.n921 avss.n19 9.44208
R5120 avss.n901 avss.n21 9.44208
R5121 avss.n969 avss.n23 9.44208
R5122 avss.n24 avss.n1021 9.44208
R5123 avss.n989 avss.n25 9.44208
R5124 avss.n1178 avss.n26 9.44208
R5125 avss.n359 avss.n27 9.44208
R5126 avss.n1220 avss.n29 9.44208
R5127 avss.n315 avss.n30 9.44208
R5128 avss.n31 avss.n1257 9.44208
R5129 avss.n32 avss.n552 9.44208
R5130 avss.n508 avss.n35 9.44208
R5131 avss.n36 avss.n480 9.44208
R5132 avss.n464 avss.n38 9.44208
R5133 avss.n39 avss.n217 9.44208
R5134 avss.n1280 avss.n40 9.44208
R5135 avss.n1093 avss.n41 9.44208
R5136 avss.n42 avss.n1073 9.44208
R5137 avss.n44 avss.n1125 9.44208
R5138 avss.n838 avss.n47 9.44208
R5139 avss.n48 avss.n618 9.44208
R5140 avss.n50 avss.n781 9.44208
R5141 avss.n51 avss.n140 9.44208
R5142 avss.n736 avss.n54 9.44208
R5143 avss.n1383 avss.n55 9.44208
R5144 avss.n190 avss.n187 9.10697
R5145 avss.n960 avss.n959 9.10697
R5146 avss.n1374 avss.n1373 9.10697
R5147 avss.n479 avss.n427 8.9796
R5148 avss.n1195 avss.n362 8.9796
R5149 avss.n1035 avss.n1034 8.9796
R5150 avss.t16 avss.n979 8.90138
R5151 avss.n1350 avss.n157 8.5556
R5152 avss.n1154 avss.n382 8.4903
R5153 avss.n1352 avss.t123 8.0645
R5154 avss.t127 avss.n1341 8.0645
R5155 avss.t131 avss.n952 8.0645
R5156 avss.n753 avss.t117 8.0645
R5157 avss.n1079 avss.t125 8.0005
R5158 avss.n1290 avss.t119 8.0005
R5159 avss.t121 avss.n325 8.0005
R5160 avss.n1156 avss.t129 8.0005
R5161 avss.n515 avss.n514 7.85793
R5162 avss.n883 avss.n871 7.63006
R5163 avss.n735 avss.n710 7.63006
R5164 avss.n1189 avss.n1188 7.567
R5165 avss.n473 avss.n472 7.567
R5166 avss.n188 avss.n56 5.6142
R5167 avss.n57 avss.n1037 5.54913
R5168 avss.n55 avss.n94 3.15232
R5169 avss.n91 avss.n50 3.15232
R5170 avss.n47 avss.n46 3.15232
R5171 avss.n44 avss.n89 3.15232
R5172 avss.n87 avss.n41 3.15232
R5173 avss.n86 avss.n40 3.15232
R5174 avss.n83 avss.n36 3.15232
R5175 avss.n79 avss.n30 3.15232
R5176 avss.n77 avss.n27 3.15232
R5177 avss.n74 avss.n24 3.15232
R5178 avss.n23 avss.n73 3.15232
R5179 avss.n19 avss.n18 3.15232
R5180 avss.n13 avss.n12 3.15232
R5181 avss.n6 avss.n5 3.15232
R5182 avss.n35 avss.n34 3.02559
R5183 avss.n514 avss.n34 2.02822
R5184 avss.n1367 avss.n51 1.99226
R5185 avss.n39 avss.n1295 1.99226
R5186 avss.n1074 avss.n32 1.99226
R5187 avss.n29 avss.n28 1.99226
R5188 avss.n1161 avss.n25 1.99226
R5189 avss.n899 avss.n16 1.99226
R5190 avss.n1338 avss.n14 1.99226
R5191 avss.n1408 avss.n3 1.99226
R5192 avss.n54 avss.n53 1.60413
R5193 avss.n56 avss.n48 1.60413
R5194 avss.n57 avss.n42 1.60413
R5195 avss.n38 avss.n37 1.60413
R5196 avss.n1258 avss.n31 1.60413
R5197 avss.n1162 avss.n26 1.60413
R5198 avss.n21 avss.n900 1.60413
R5199 avss.n10 avss.n9 1.60413
R5200 avss.n93 avss.n53 1.54869
R5201 avss.n90 avss.n56 1.54869
R5202 avss.n57 avss.n88 1.54869
R5203 avss.n84 avss.n37 1.54869
R5204 avss.n80 avss.n1258 1.54869
R5205 avss.n76 avss.n1162 1.54869
R5206 avss.n900 avss.n72 1.54869
R5207 avss.n69 avss.n9 1.54869
R5208 avss.n1345 avss.n1344 1.44312
R5209 avss.n1118 avss.n1117 1.44312
R5210 avss.n1320 avss.n1319 1.24768
R5211 avss.n958 avss.n588 1.24768
R5212 avss.n1372 avss.n134 1.24768
R5213 avss.n900 avss.n899 1.21999
R5214 avss.n1162 avss.n1161 1.21999
R5215 avss.n1258 avss.n28 1.21999
R5216 avss.n1295 avss.n37 1.21999
R5217 avss.n1367 avss.n53 1.21999
R5218 avss.n1408 avss.n9 1.21999
R5219 avss.n1074 avss.n57 1.21999
R5220 avss.n1338 avss.n56 1.21999
R5221 avss.n1036 avss.n553 1.18204
R5222 avss.n1191 avss.n1190 1.18204
R5223 avss.n475 avss.n474 1.18204
R5224 avss.n92 avss.n1367 1.16057
R5225 avss.n1295 avss.n85 1.16057
R5226 avss.n82 avss.n1074 1.16057
R5227 avss.n78 avss.n28 1.16057
R5228 avss.n1161 avss.n75 1.16057
R5229 avss.n899 avss.n71 1.16057
R5230 avss.n70 avss.n1338 1.16057
R5231 avss.n1408 avss.n68 1.16057
R5232 avss avss.n0 0.0005
R5233 DAC4_0.DAC3_1.DAC2_1.sw_0.XM6.G DAC4_0.DAC3_1.DAC2_1.sw_0.XM6.G.t1 642.13
R5234 DAC4_0.DAC3_1.DAC2_1.sw_0.XM6.G.t4 DAC4_0.DAC3_1.DAC2_1.sw_0.XM6.G.n1 315.93
R5235 DAC4_0.DAC3_1.DAC2_1.sw_0.XM6.G.n0 DAC4_0.DAC3_1.DAC2_1.sw_0.XM6.G.t5 315.913
R5236 DAC4_0.DAC3_1.DAC2_1.sw_0.XM6.G DAC4_0.DAC3_1.DAC2_1.sw_0.XM6.G.t5 306.24
R5237 DAC4_0.DAC3_1.DAC2_1.sw_0.XM6.G DAC4_0.DAC3_1.DAC2_1.sw_0.XM6.G.t4 306.24
R5238 DAC4_0.DAC3_1.DAC2_1.sw_0.XM6.G DAC4_0.DAC3_1.DAC2_1.sw_0.XM6.G.t0 219.8
R5239 DAC4_0.DAC3_1.DAC2_1.sw_0.XM6.G.n3 DAC4_0.DAC3_1.DAC2_1.sw_0.XM6.G.t2 146.077
R5240 DAC4_0.DAC3_1.DAC2_1.sw_0.XM6.G.n4 DAC4_0.DAC3_1.DAC2_1.sw_0.XM6.G.t3 146.026
R5241 DAC4_0.DAC3_1.DAC2_1.sw_0.XM6.G DAC4_0.DAC3_1.DAC2_1.sw_0.XM6.G.n0 10.8091
R5242 DAC4_0.DAC3_1.DAC2_1.sw_0.XM6.G.n0 DAC4_0.DAC3_1.DAC2_1.sw_0.XM6.G 10.6655
R5243 DAC4_0.DAC3_1.DAC2_1.sw_0.XM6.G.n2 DAC4_0.DAC3_1.DAC2_1.sw_0.XM6.G 9.75229
R5244 DAC4_0.DAC3_1.DAC2_1.sw_0.XM6.G.n2 DAC4_0.DAC3_1.DAC2_1.sw_0.XM6.G 9.3005
R5245 DAC4_0.DAC3_1.DAC2_1.sw_0.XM6.G.n1 DAC4_0.DAC3_1.DAC2_1.sw_0.XM6.G.n3 6.27093
R5246 DAC4_0.DAC3_1.DAC2_1.sw_0.XM6.G.n0 DAC4_0.DAC3_1.DAC2_1.sw_0.XM6.G.n4 5.39071
R5247 DAC4_0.DAC3_1.DAC2_1.sw_0.XM6.G.n4 DAC4_0.DAC3_1.DAC2_1.sw_0.XM6.G 4.7143
R5248 DAC4_0.DAC3_1.DAC2_1.sw_0.XM6.G.n3 DAC4_0.DAC3_1.DAC2_1.sw_0.XM6.G 4.68397
R5249 DAC4_0.DAC3_1.DAC2_1.sw_0.XM6.G.n0 DAC4_0.DAC3_1.DAC2_1.sw_0.XM6.G.n2 1.87089
R5250 DAC4_0.DAC3_1.DAC2_1.sw_0.XM6.G.n2 DAC4_0.DAC3_1.DAC2_1.sw_0.XM6.G.n1 1.47636
R5251 DAC4_0.DAC3_1.DAC2_1.sw_2.XM6.G DAC4_0.DAC3_1.DAC2_1.sw_2.XM6.G.t1 642.13
R5252 DAC4_0.DAC3_1.DAC2_1.sw_2.XM6.G.t4 DAC4_0.DAC3_1.DAC2_1.sw_2.XM6.G.n1 315.93
R5253 DAC4_0.DAC3_1.DAC2_1.sw_2.XM6.G.n0 DAC4_0.DAC3_1.DAC2_1.sw_2.XM6.G.t5 315.913
R5254 DAC4_0.DAC3_1.DAC2_1.sw_2.XM6.G DAC4_0.DAC3_1.DAC2_1.sw_2.XM6.G.t5 306.24
R5255 DAC4_0.DAC3_1.DAC2_1.sw_2.XM6.G DAC4_0.DAC3_1.DAC2_1.sw_2.XM6.G.t4 306.24
R5256 DAC4_0.DAC3_1.DAC2_1.sw_2.XM6.G DAC4_0.DAC3_1.DAC2_1.sw_2.XM6.G.t0 219.8
R5257 DAC4_0.DAC3_1.DAC2_1.sw_2.XM6.G.n3 DAC4_0.DAC3_1.DAC2_1.sw_2.XM6.G.t2 146.077
R5258 DAC4_0.DAC3_1.DAC2_1.sw_2.XM6.G.n4 DAC4_0.DAC3_1.DAC2_1.sw_2.XM6.G.t3 146.026
R5259 DAC4_0.DAC3_1.DAC2_1.sw_2.XM6.G DAC4_0.DAC3_1.DAC2_1.sw_2.XM6.G.n0 10.8091
R5260 DAC4_0.DAC3_1.DAC2_1.sw_2.XM6.G.n0 DAC4_0.DAC3_1.DAC2_1.sw_2.XM6.G 10.6655
R5261 DAC4_0.DAC3_1.DAC2_1.sw_2.XM6.G.n2 DAC4_0.DAC3_1.DAC2_1.sw_2.XM6.G 9.75229
R5262 DAC4_0.DAC3_1.DAC2_1.sw_2.XM6.G.n2 DAC4_0.DAC3_1.DAC2_1.sw_2.XM6.G 9.3005
R5263 DAC4_0.DAC3_1.DAC2_1.sw_2.XM6.G.n1 DAC4_0.DAC3_1.DAC2_1.sw_2.XM6.G.n3 6.27093
R5264 DAC4_0.DAC3_1.DAC2_1.sw_2.XM6.G.n0 DAC4_0.DAC3_1.DAC2_1.sw_2.XM6.G.n4 5.39071
R5265 DAC4_0.DAC3_1.DAC2_1.sw_2.XM6.G.n4 DAC4_0.DAC3_1.DAC2_1.sw_2.XM6.G 4.7143
R5266 DAC4_0.DAC3_1.DAC2_1.sw_2.XM6.G.n3 DAC4_0.DAC3_1.DAC2_1.sw_2.XM6.G 4.68397
R5267 DAC4_0.DAC3_1.DAC2_1.sw_2.XM6.G.n0 DAC4_0.DAC3_1.DAC2_1.sw_2.XM6.G.n2 1.87089
R5268 DAC4_0.DAC3_1.DAC2_1.sw_2.XM6.G.n2 DAC4_0.DAC3_1.DAC2_1.sw_2.XM6.G.n1 1.47636
R5269 DAC4_0.DAC3_1.DAC2_1.sw_1.XM6.G DAC4_0.DAC3_1.DAC2_1.sw_1.XM6.G.t1 642.13
R5270 DAC4_0.DAC3_1.DAC2_1.sw_1.XM6.G.t4 DAC4_0.DAC3_1.DAC2_1.sw_1.XM6.G.n1 315.93
R5271 DAC4_0.DAC3_1.DAC2_1.sw_1.XM6.G.n0 DAC4_0.DAC3_1.DAC2_1.sw_1.XM6.G.t5 315.913
R5272 DAC4_0.DAC3_1.DAC2_1.sw_1.XM6.G DAC4_0.DAC3_1.DAC2_1.sw_1.XM6.G.t5 306.24
R5273 DAC4_0.DAC3_1.DAC2_1.sw_1.XM6.G DAC4_0.DAC3_1.DAC2_1.sw_1.XM6.G.t4 306.24
R5274 DAC4_0.DAC3_1.DAC2_1.sw_1.XM6.G DAC4_0.DAC3_1.DAC2_1.sw_1.XM6.G.t0 219.8
R5275 DAC4_0.DAC3_1.DAC2_1.sw_1.XM6.G.n3 DAC4_0.DAC3_1.DAC2_1.sw_1.XM6.G.t2 146.077
R5276 DAC4_0.DAC3_1.DAC2_1.sw_1.XM6.G.n4 DAC4_0.DAC3_1.DAC2_1.sw_1.XM6.G.t3 146.026
R5277 DAC4_0.DAC3_1.DAC2_1.sw_1.XM6.G DAC4_0.DAC3_1.DAC2_1.sw_1.XM6.G.n0 10.8091
R5278 DAC4_0.DAC3_1.DAC2_1.sw_1.XM6.G.n0 DAC4_0.DAC3_1.DAC2_1.sw_1.XM6.G 10.6655
R5279 DAC4_0.DAC3_1.DAC2_1.sw_1.XM6.G.n2 DAC4_0.DAC3_1.DAC2_1.sw_1.XM6.G 9.75229
R5280 DAC4_0.DAC3_1.DAC2_1.sw_1.XM6.G.n2 DAC4_0.DAC3_1.DAC2_1.sw_1.XM6.G 9.3005
R5281 DAC4_0.DAC3_1.DAC2_1.sw_1.XM6.G.n1 DAC4_0.DAC3_1.DAC2_1.sw_1.XM6.G.n3 6.27093
R5282 DAC4_0.DAC3_1.DAC2_1.sw_1.XM6.G.n0 DAC4_0.DAC3_1.DAC2_1.sw_1.XM6.G.n4 5.39071
R5283 DAC4_0.DAC3_1.DAC2_1.sw_1.XM6.G.n4 DAC4_0.DAC3_1.DAC2_1.sw_1.XM6.G 4.7143
R5284 DAC4_0.DAC3_1.DAC2_1.sw_1.XM6.G.n3 DAC4_0.DAC3_1.DAC2_1.sw_1.XM6.G 4.68397
R5285 DAC4_0.DAC3_1.DAC2_1.sw_1.XM6.G.n0 DAC4_0.DAC3_1.DAC2_1.sw_1.XM6.G.n2 1.87089
R5286 DAC4_0.DAC3_1.DAC2_1.sw_1.XM6.G.n2 DAC4_0.DAC3_1.DAC2_1.sw_1.XM6.G.n1 1.47636
R5287 DAC4_0.DAC3_1.sw_0.XM6.G DAC4_0.DAC3_1.sw_0.XM6.G.t1 642.13
R5288 DAC4_0.DAC3_1.sw_0.XM6.G.t4 DAC4_0.DAC3_1.sw_0.XM6.G.n1 315.93
R5289 DAC4_0.DAC3_1.sw_0.XM6.G.n0 DAC4_0.DAC3_1.sw_0.XM6.G.t5 315.913
R5290 DAC4_0.DAC3_1.sw_0.XM6.G DAC4_0.DAC3_1.sw_0.XM6.G.t5 306.24
R5291 DAC4_0.DAC3_1.sw_0.XM6.G DAC4_0.DAC3_1.sw_0.XM6.G.t4 306.24
R5292 DAC4_0.DAC3_1.sw_0.XM6.G DAC4_0.DAC3_1.sw_0.XM6.G.t0 219.8
R5293 DAC4_0.DAC3_1.sw_0.XM6.G.n3 DAC4_0.DAC3_1.sw_0.XM6.G.t2 146.077
R5294 DAC4_0.DAC3_1.sw_0.XM6.G.n4 DAC4_0.DAC3_1.sw_0.XM6.G.t3 146.026
R5295 DAC4_0.DAC3_1.sw_0.XM6.G DAC4_0.DAC3_1.sw_0.XM6.G.n0 10.8091
R5296 DAC4_0.DAC3_1.sw_0.XM6.G.n0 DAC4_0.DAC3_1.sw_0.XM6.G 10.6655
R5297 DAC4_0.DAC3_1.sw_0.XM6.G.n2 DAC4_0.DAC3_1.sw_0.XM6.G 9.75229
R5298 DAC4_0.DAC3_1.sw_0.XM6.G.n2 DAC4_0.DAC3_1.sw_0.XM6.G 9.3005
R5299 DAC4_0.DAC3_1.sw_0.XM6.G.n1 DAC4_0.DAC3_1.sw_0.XM6.G.n3 6.27093
R5300 DAC4_0.DAC3_1.sw_0.XM6.G.n0 DAC4_0.DAC3_1.sw_0.XM6.G.n4 5.39071
R5301 DAC4_0.DAC3_1.sw_0.XM6.G.n4 DAC4_0.DAC3_1.sw_0.XM6.G 4.7143
R5302 DAC4_0.DAC3_1.sw_0.XM6.G.n3 DAC4_0.DAC3_1.sw_0.XM6.G 4.68397
R5303 DAC4_0.DAC3_1.sw_0.XM6.G.n0 DAC4_0.DAC3_1.sw_0.XM6.G.n2 1.87089
R5304 DAC4_0.DAC3_1.sw_0.XM6.G.n2 DAC4_0.DAC3_1.sw_0.XM6.G.n1 1.47636
R5305 DAC4_0.DAC3_1.DAC2_0.sw_0.XM6.G DAC4_0.DAC3_1.DAC2_0.sw_0.XM6.G.t1 642.13
R5306 DAC4_0.DAC3_1.DAC2_0.sw_0.XM6.G.t4 DAC4_0.DAC3_1.DAC2_0.sw_0.XM6.G.n1 315.93
R5307 DAC4_0.DAC3_1.DAC2_0.sw_0.XM6.G.n0 DAC4_0.DAC3_1.DAC2_0.sw_0.XM6.G.t5 315.913
R5308 DAC4_0.DAC3_1.DAC2_0.sw_0.XM6.G DAC4_0.DAC3_1.DAC2_0.sw_0.XM6.G.t5 306.24
R5309 DAC4_0.DAC3_1.DAC2_0.sw_0.XM6.G DAC4_0.DAC3_1.DAC2_0.sw_0.XM6.G.t4 306.24
R5310 DAC4_0.DAC3_1.DAC2_0.sw_0.XM6.G DAC4_0.DAC3_1.DAC2_0.sw_0.XM6.G.t0 219.8
R5311 DAC4_0.DAC3_1.DAC2_0.sw_0.XM6.G.n3 DAC4_0.DAC3_1.DAC2_0.sw_0.XM6.G.t2 146.077
R5312 DAC4_0.DAC3_1.DAC2_0.sw_0.XM6.G.n4 DAC4_0.DAC3_1.DAC2_0.sw_0.XM6.G.t3 146.026
R5313 DAC4_0.DAC3_1.DAC2_0.sw_0.XM6.G DAC4_0.DAC3_1.DAC2_0.sw_0.XM6.G.n0 10.8091
R5314 DAC4_0.DAC3_1.DAC2_0.sw_0.XM6.G.n0 DAC4_0.DAC3_1.DAC2_0.sw_0.XM6.G 10.6655
R5315 DAC4_0.DAC3_1.DAC2_0.sw_0.XM6.G.n2 DAC4_0.DAC3_1.DAC2_0.sw_0.XM6.G 9.75229
R5316 DAC4_0.DAC3_1.DAC2_0.sw_0.XM6.G.n2 DAC4_0.DAC3_1.DAC2_0.sw_0.XM6.G 9.3005
R5317 DAC4_0.DAC3_1.DAC2_0.sw_0.XM6.G.n1 DAC4_0.DAC3_1.DAC2_0.sw_0.XM6.G.n3 6.27093
R5318 DAC4_0.DAC3_1.DAC2_0.sw_0.XM6.G.n0 DAC4_0.DAC3_1.DAC2_0.sw_0.XM6.G.n4 5.39071
R5319 DAC4_0.DAC3_1.DAC2_0.sw_0.XM6.G.n4 DAC4_0.DAC3_1.DAC2_0.sw_0.XM6.G 4.7143
R5320 DAC4_0.DAC3_1.DAC2_0.sw_0.XM6.G.n3 DAC4_0.DAC3_1.DAC2_0.sw_0.XM6.G 4.68397
R5321 DAC4_0.DAC3_1.DAC2_0.sw_0.XM6.G.n0 DAC4_0.DAC3_1.DAC2_0.sw_0.XM6.G.n2 1.87089
R5322 DAC4_0.DAC3_1.DAC2_0.sw_0.XM6.G.n2 DAC4_0.DAC3_1.DAC2_0.sw_0.XM6.G.n1 1.47636
R5323 DAC4_0.DAC3_1.DAC2_0.sw_2.XM6.G DAC4_0.DAC3_1.DAC2_0.sw_2.XM6.G.t1 642.13
R5324 DAC4_0.DAC3_1.DAC2_0.sw_2.XM6.G.t4 DAC4_0.DAC3_1.DAC2_0.sw_2.XM6.G.n1 315.93
R5325 DAC4_0.DAC3_1.DAC2_0.sw_2.XM6.G.n0 DAC4_0.DAC3_1.DAC2_0.sw_2.XM6.G.t5 315.913
R5326 DAC4_0.DAC3_1.DAC2_0.sw_2.XM6.G DAC4_0.DAC3_1.DAC2_0.sw_2.XM6.G.t5 306.24
R5327 DAC4_0.DAC3_1.DAC2_0.sw_2.XM6.G DAC4_0.DAC3_1.DAC2_0.sw_2.XM6.G.t4 306.24
R5328 DAC4_0.DAC3_1.DAC2_0.sw_2.XM6.G DAC4_0.DAC3_1.DAC2_0.sw_2.XM6.G.t0 219.8
R5329 DAC4_0.DAC3_1.DAC2_0.sw_2.XM6.G.n3 DAC4_0.DAC3_1.DAC2_0.sw_2.XM6.G.t2 146.077
R5330 DAC4_0.DAC3_1.DAC2_0.sw_2.XM6.G.n4 DAC4_0.DAC3_1.DAC2_0.sw_2.XM6.G.t3 146.026
R5331 DAC4_0.DAC3_1.DAC2_0.sw_2.XM6.G DAC4_0.DAC3_1.DAC2_0.sw_2.XM6.G.n0 10.8091
R5332 DAC4_0.DAC3_1.DAC2_0.sw_2.XM6.G.n0 DAC4_0.DAC3_1.DAC2_0.sw_2.XM6.G 10.6655
R5333 DAC4_0.DAC3_1.DAC2_0.sw_2.XM6.G.n2 DAC4_0.DAC3_1.DAC2_0.sw_2.XM6.G 9.75229
R5334 DAC4_0.DAC3_1.DAC2_0.sw_2.XM6.G.n2 DAC4_0.DAC3_1.DAC2_0.sw_2.XM6.G 9.3005
R5335 DAC4_0.DAC3_1.DAC2_0.sw_2.XM6.G.n1 DAC4_0.DAC3_1.DAC2_0.sw_2.XM6.G.n3 6.27093
R5336 DAC4_0.DAC3_1.DAC2_0.sw_2.XM6.G.n0 DAC4_0.DAC3_1.DAC2_0.sw_2.XM6.G.n4 5.39071
R5337 DAC4_0.DAC3_1.DAC2_0.sw_2.XM6.G.n4 DAC4_0.DAC3_1.DAC2_0.sw_2.XM6.G 4.7143
R5338 DAC4_0.DAC3_1.DAC2_0.sw_2.XM6.G.n3 DAC4_0.DAC3_1.DAC2_0.sw_2.XM6.G 4.68397
R5339 DAC4_0.DAC3_1.DAC2_0.sw_2.XM6.G.n0 DAC4_0.DAC3_1.DAC2_0.sw_2.XM6.G.n2 1.87089
R5340 DAC4_0.DAC3_1.DAC2_0.sw_2.XM6.G.n2 DAC4_0.DAC3_1.DAC2_0.sw_2.XM6.G.n1 1.47636
R5341 DAC4_1.DAC3_1.vrefh DAC4_1.DAC3_1.vrefh.t2 642.13
R5342 DAC4_1.DAC3_1.vrefh DAC4_1.DAC3_1.vrefh.t0 219.8
R5343 DAC4_1.DAC3_1.vrefh.n0 DAC4_1.DAC3_1.vrefh 42.6931
R5344 DAC4_1.DAC3_1.vrefh.n1 DAC4_1.DAC3_1.vrefh 19.4759
R5345 DAC4_1.DAC3_1.vrefh DAC4_1.DAC3_1.vrefh.n1 14.7779
R5346 DAC4_1.DAC3_1.vrefh.t1 DAC4_1.DAC3_1.vrefh 11.8435
R5347 DAC4_1.DAC3_1.vrefh.n0 DAC4_1.DAC3_1.vrefh.t1 11.7239
R5348 DAC4_1.DAC3_1.vrefh.n1 DAC4_1.DAC3_1.vrefh 6.88992
R5349 DAC4_1.DAC3_1.vrefh.n0 DAC4_1.DAC3_1.vrefh 1.87525
R5350 DAC4_1.DAC3_1.vrefh DAC4_1.DAC3_1.vrefh.t1 1.61666
R5351 DAC4_1.DAC3_1.vrefh DAC4_1.DAC3_1.vrefh.n0 1.41554
R5352 DAC4_0.DAC3_1.DAC2_0.sw_1.XM6.G DAC4_0.DAC3_1.DAC2_0.sw_1.XM6.G.t1 642.13
R5353 DAC4_0.DAC3_1.DAC2_0.sw_1.XM6.G.t4 DAC4_0.DAC3_1.DAC2_0.sw_1.XM6.G.n1 315.93
R5354 DAC4_0.DAC3_1.DAC2_0.sw_1.XM6.G.n0 DAC4_0.DAC3_1.DAC2_0.sw_1.XM6.G.t5 315.913
R5355 DAC4_0.DAC3_1.DAC2_0.sw_1.XM6.G DAC4_0.DAC3_1.DAC2_0.sw_1.XM6.G.t5 306.24
R5356 DAC4_0.DAC3_1.DAC2_0.sw_1.XM6.G DAC4_0.DAC3_1.DAC2_0.sw_1.XM6.G.t4 306.24
R5357 DAC4_0.DAC3_1.DAC2_0.sw_1.XM6.G DAC4_0.DAC3_1.DAC2_0.sw_1.XM6.G.t0 219.8
R5358 DAC4_0.DAC3_1.DAC2_0.sw_1.XM6.G.n3 DAC4_0.DAC3_1.DAC2_0.sw_1.XM6.G.t2 146.077
R5359 DAC4_0.DAC3_1.DAC2_0.sw_1.XM6.G.n4 DAC4_0.DAC3_1.DAC2_0.sw_1.XM6.G.t3 146.026
R5360 DAC4_0.DAC3_1.DAC2_0.sw_1.XM6.G DAC4_0.DAC3_1.DAC2_0.sw_1.XM6.G.n0 10.8091
R5361 DAC4_0.DAC3_1.DAC2_0.sw_1.XM6.G.n0 DAC4_0.DAC3_1.DAC2_0.sw_1.XM6.G 10.6655
R5362 DAC4_0.DAC3_1.DAC2_0.sw_1.XM6.G.n2 DAC4_0.DAC3_1.DAC2_0.sw_1.XM6.G 9.75229
R5363 DAC4_0.DAC3_1.DAC2_0.sw_1.XM6.G.n2 DAC4_0.DAC3_1.DAC2_0.sw_1.XM6.G 9.3005
R5364 DAC4_0.DAC3_1.DAC2_0.sw_1.XM6.G.n1 DAC4_0.DAC3_1.DAC2_0.sw_1.XM6.G.n3 6.27093
R5365 DAC4_0.DAC3_1.DAC2_0.sw_1.XM6.G.n0 DAC4_0.DAC3_1.DAC2_0.sw_1.XM6.G.n4 5.39071
R5366 DAC4_0.DAC3_1.DAC2_0.sw_1.XM6.G.n4 DAC4_0.DAC3_1.DAC2_0.sw_1.XM6.G 4.7143
R5367 DAC4_0.DAC3_1.DAC2_0.sw_1.XM6.G.n3 DAC4_0.DAC3_1.DAC2_0.sw_1.XM6.G 4.68397
R5368 DAC4_0.DAC3_1.DAC2_0.sw_1.XM6.G.n0 DAC4_0.DAC3_1.DAC2_0.sw_1.XM6.G.n2 1.87089
R5369 DAC4_0.DAC3_1.DAC2_0.sw_1.XM6.G.n2 DAC4_0.DAC3_1.DAC2_0.sw_1.XM6.G.n1 1.47636
R5370 DAC4_0.sw_0.XM6.G DAC4_0.sw_0.XM6.G.t1 642.13
R5371 DAC4_0.sw_0.XM6.G.t4 DAC4_0.sw_0.XM6.G.n1 315.93
R5372 DAC4_0.sw_0.XM6.G.n0 DAC4_0.sw_0.XM6.G.t5 315.913
R5373 DAC4_0.sw_0.XM6.G DAC4_0.sw_0.XM6.G.t5 306.24
R5374 DAC4_0.sw_0.XM6.G DAC4_0.sw_0.XM6.G.t4 306.24
R5375 DAC4_0.sw_0.XM6.G DAC4_0.sw_0.XM6.G.t0 219.8
R5376 DAC4_0.sw_0.XM6.G.n3 DAC4_0.sw_0.XM6.G.t2 146.077
R5377 DAC4_0.sw_0.XM6.G.n4 DAC4_0.sw_0.XM6.G.t3 146.026
R5378 DAC4_0.sw_0.XM6.G DAC4_0.sw_0.XM6.G.n0 10.8091
R5379 DAC4_0.sw_0.XM6.G.n0 DAC4_0.sw_0.XM6.G 10.6655
R5380 DAC4_0.sw_0.XM6.G.n2 DAC4_0.sw_0.XM6.G 9.75229
R5381 DAC4_0.sw_0.XM6.G.n2 DAC4_0.sw_0.XM6.G 9.3005
R5382 DAC4_0.sw_0.XM6.G.n1 DAC4_0.sw_0.XM6.G.n3 6.27093
R5383 DAC4_0.sw_0.XM6.G.n0 DAC4_0.sw_0.XM6.G.n4 5.39071
R5384 DAC4_0.sw_0.XM6.G.n4 DAC4_0.sw_0.XM6.G 4.7143
R5385 DAC4_0.sw_0.XM6.G.n3 DAC4_0.sw_0.XM6.G 4.68397
R5386 DAC4_0.sw_0.XM6.G.n0 DAC4_0.sw_0.XM6.G.n2 1.87089
R5387 DAC4_0.sw_0.XM6.G.n2 DAC4_0.sw_0.XM6.G.n1 1.47636
R5388 sw_0.XM6.G sw_0.XM6.G.t1 642.13
R5389 sw_0.XM6.G.t5 sw_0.XM6.G.n1 315.93
R5390 sw_0.XM6.G.n0 sw_0.XM6.G.t4 315.913
R5391 sw_0.XM6.G sw_0.XM6.G.t5 306.24
R5392 sw_0.XM6.G sw_0.XM6.G.t4 306.24
R5393 sw_0.XM6.G sw_0.XM6.G.t0 219.8
R5394 sw_0.XM6.G.n4 sw_0.XM6.G.t3 146.077
R5395 sw_0.XM6.G.n3 sw_0.XM6.G.t2 146.06
R5396 sw_0.XM6.G sw_0.XM6.G.n0 10.7387
R5397 sw_0.XM6.G.n0 sw_0.XM6.G 10.6698
R5398 sw_0.XM6.G.n2 sw_0.XM6.G 9.69714
R5399 sw_0.XM6.G.n2 sw_0.XM6.G 9.3005
R5400 sw_0.XM6.G.n1 sw_0.XM6.G.n4 6.27093
R5401 sw_0.XM6.G.n0 sw_0.XM6.G.n3 5.47727
R5402 sw_0.XM6.G.n4 sw_0.XM6.G 4.68397
R5403 sw_0.XM6.G.n3 sw_0.XM6.G 4.6762
R5404 sw_0.XM6.G.n0 sw_0.XM6.G.n2 1.87089
R5405 sw_0.XM6.G.n2 sw_0.XM6.G.n1 1.47269
R5406 DAC4_0.DAC3_1.vrefh DAC4_0.DAC3_1.vrefh.t0 642.13
R5407 DAC4_0.DAC3_1.vrefh DAC4_0.DAC3_1.vrefh.t1 219.8
R5408 DAC4_0.DAC3_1.vrefh DAC4_0.DAC3_1.vrefh.n0 19.4759
R5409 DAC4_0.DAC3_1.vrefh.t2 DAC4_0.DAC3_1.vrefh 16.119
R5410 DAC4_0.DAC3_1.vrefh DAC4_0.DAC3_1.vrefh.t2 15.4869
R5411 DAC4_0.DAC3_1.vrefh.n0 DAC4_0.DAC3_1.vrefh 14.7779
R5412 DAC4_0.DAC3_1.vrefh.n0 DAC4_0.DAC3_1.vrefh 6.93707
R5413 DAC4_0.DAC3_1.vrefh.t2 DAC4_0.DAC3_1.vrefh 2.39242
R5414 DAC4_0.DAC3_0.DAC2_1.sw_0.XM6.G DAC4_0.DAC3_0.DAC2_1.sw_0.XM6.G.t1 642.13
R5415 DAC4_0.DAC3_0.DAC2_1.sw_0.XM6.G.t4 DAC4_0.DAC3_0.DAC2_1.sw_0.XM6.G.n1 315.93
R5416 DAC4_0.DAC3_0.DAC2_1.sw_0.XM6.G.n0 DAC4_0.DAC3_0.DAC2_1.sw_0.XM6.G.t5 315.913
R5417 DAC4_0.DAC3_0.DAC2_1.sw_0.XM6.G DAC4_0.DAC3_0.DAC2_1.sw_0.XM6.G.t5 306.24
R5418 DAC4_0.DAC3_0.DAC2_1.sw_0.XM6.G DAC4_0.DAC3_0.DAC2_1.sw_0.XM6.G.t4 306.24
R5419 DAC4_0.DAC3_0.DAC2_1.sw_0.XM6.G DAC4_0.DAC3_0.DAC2_1.sw_0.XM6.G.t0 219.8
R5420 DAC4_0.DAC3_0.DAC2_1.sw_0.XM6.G.n3 DAC4_0.DAC3_0.DAC2_1.sw_0.XM6.G.t2 146.077
R5421 DAC4_0.DAC3_0.DAC2_1.sw_0.XM6.G.n4 DAC4_0.DAC3_0.DAC2_1.sw_0.XM6.G.t3 146.026
R5422 DAC4_0.DAC3_0.DAC2_1.sw_0.XM6.G DAC4_0.DAC3_0.DAC2_1.sw_0.XM6.G.n0 10.8091
R5423 DAC4_0.DAC3_0.DAC2_1.sw_0.XM6.G.n0 DAC4_0.DAC3_0.DAC2_1.sw_0.XM6.G 10.6655
R5424 DAC4_0.DAC3_0.DAC2_1.sw_0.XM6.G.n2 DAC4_0.DAC3_0.DAC2_1.sw_0.XM6.G 9.75229
R5425 DAC4_0.DAC3_0.DAC2_1.sw_0.XM6.G.n2 DAC4_0.DAC3_0.DAC2_1.sw_0.XM6.G 9.3005
R5426 DAC4_0.DAC3_0.DAC2_1.sw_0.XM6.G.n1 DAC4_0.DAC3_0.DAC2_1.sw_0.XM6.G.n3 6.27093
R5427 DAC4_0.DAC3_0.DAC2_1.sw_0.XM6.G.n0 DAC4_0.DAC3_0.DAC2_1.sw_0.XM6.G.n4 5.39071
R5428 DAC4_0.DAC3_0.DAC2_1.sw_0.XM6.G.n4 DAC4_0.DAC3_0.DAC2_1.sw_0.XM6.G 4.7143
R5429 DAC4_0.DAC3_0.DAC2_1.sw_0.XM6.G.n3 DAC4_0.DAC3_0.DAC2_1.sw_0.XM6.G 4.68397
R5430 DAC4_0.DAC3_0.DAC2_1.sw_0.XM6.G.n0 DAC4_0.DAC3_0.DAC2_1.sw_0.XM6.G.n2 1.87089
R5431 DAC4_0.DAC3_0.DAC2_1.sw_0.XM6.G.n2 DAC4_0.DAC3_0.DAC2_1.sw_0.XM6.G.n1 1.47636
R5432 DAC4_0.DAC3_0.DAC2_1.sw_2.XM6.G DAC4_0.DAC3_0.DAC2_1.sw_2.XM6.G.t1 642.13
R5433 DAC4_0.DAC3_0.DAC2_1.sw_2.XM6.G.t4 DAC4_0.DAC3_0.DAC2_1.sw_2.XM6.G.n1 315.93
R5434 DAC4_0.DAC3_0.DAC2_1.sw_2.XM6.G.n0 DAC4_0.DAC3_0.DAC2_1.sw_2.XM6.G.t5 315.913
R5435 DAC4_0.DAC3_0.DAC2_1.sw_2.XM6.G DAC4_0.DAC3_0.DAC2_1.sw_2.XM6.G.t5 306.24
R5436 DAC4_0.DAC3_0.DAC2_1.sw_2.XM6.G DAC4_0.DAC3_0.DAC2_1.sw_2.XM6.G.t4 306.24
R5437 DAC4_0.DAC3_0.DAC2_1.sw_2.XM6.G DAC4_0.DAC3_0.DAC2_1.sw_2.XM6.G.t0 219.8
R5438 DAC4_0.DAC3_0.DAC2_1.sw_2.XM6.G.n3 DAC4_0.DAC3_0.DAC2_1.sw_2.XM6.G.t2 146.077
R5439 DAC4_0.DAC3_0.DAC2_1.sw_2.XM6.G.n4 DAC4_0.DAC3_0.DAC2_1.sw_2.XM6.G.t3 146.026
R5440 DAC4_0.DAC3_0.DAC2_1.sw_2.XM6.G DAC4_0.DAC3_0.DAC2_1.sw_2.XM6.G.n0 10.8091
R5441 DAC4_0.DAC3_0.DAC2_1.sw_2.XM6.G.n0 DAC4_0.DAC3_0.DAC2_1.sw_2.XM6.G 10.6655
R5442 DAC4_0.DAC3_0.DAC2_1.sw_2.XM6.G.n2 DAC4_0.DAC3_0.DAC2_1.sw_2.XM6.G 9.75229
R5443 DAC4_0.DAC3_0.DAC2_1.sw_2.XM6.G.n2 DAC4_0.DAC3_0.DAC2_1.sw_2.XM6.G 9.3005
R5444 DAC4_0.DAC3_0.DAC2_1.sw_2.XM6.G.n1 DAC4_0.DAC3_0.DAC2_1.sw_2.XM6.G.n3 6.27093
R5445 DAC4_0.DAC3_0.DAC2_1.sw_2.XM6.G.n0 DAC4_0.DAC3_0.DAC2_1.sw_2.XM6.G.n4 5.39071
R5446 DAC4_0.DAC3_0.DAC2_1.sw_2.XM6.G.n4 DAC4_0.DAC3_0.DAC2_1.sw_2.XM6.G 4.7143
R5447 DAC4_0.DAC3_0.DAC2_1.sw_2.XM6.G.n3 DAC4_0.DAC3_0.DAC2_1.sw_2.XM6.G 4.68397
R5448 DAC4_0.DAC3_0.DAC2_1.sw_2.XM6.G.n0 DAC4_0.DAC3_0.DAC2_1.sw_2.XM6.G.n2 1.87089
R5449 DAC4_0.DAC3_0.DAC2_1.sw_2.XM6.G.n2 DAC4_0.DAC3_0.DAC2_1.sw_2.XM6.G.n1 1.47636
R5450 DAC4_0.DAC3_0.DAC2_1.sw_1.XM6.G DAC4_0.DAC3_0.DAC2_1.sw_1.XM6.G.t1 642.13
R5451 DAC4_0.DAC3_0.DAC2_1.sw_1.XM6.G.t4 DAC4_0.DAC3_0.DAC2_1.sw_1.XM6.G.n1 315.93
R5452 DAC4_0.DAC3_0.DAC2_1.sw_1.XM6.G.n0 DAC4_0.DAC3_0.DAC2_1.sw_1.XM6.G.t5 315.913
R5453 DAC4_0.DAC3_0.DAC2_1.sw_1.XM6.G DAC4_0.DAC3_0.DAC2_1.sw_1.XM6.G.t5 306.24
R5454 DAC4_0.DAC3_0.DAC2_1.sw_1.XM6.G DAC4_0.DAC3_0.DAC2_1.sw_1.XM6.G.t4 306.24
R5455 DAC4_0.DAC3_0.DAC2_1.sw_1.XM6.G DAC4_0.DAC3_0.DAC2_1.sw_1.XM6.G.t0 219.8
R5456 DAC4_0.DAC3_0.DAC2_1.sw_1.XM6.G.n3 DAC4_0.DAC3_0.DAC2_1.sw_1.XM6.G.t2 146.077
R5457 DAC4_0.DAC3_0.DAC2_1.sw_1.XM6.G.n4 DAC4_0.DAC3_0.DAC2_1.sw_1.XM6.G.t3 146.026
R5458 DAC4_0.DAC3_0.DAC2_1.sw_1.XM6.G DAC4_0.DAC3_0.DAC2_1.sw_1.XM6.G.n0 10.8091
R5459 DAC4_0.DAC3_0.DAC2_1.sw_1.XM6.G.n0 DAC4_0.DAC3_0.DAC2_1.sw_1.XM6.G 10.6655
R5460 DAC4_0.DAC3_0.DAC2_1.sw_1.XM6.G.n2 DAC4_0.DAC3_0.DAC2_1.sw_1.XM6.G 9.75229
R5461 DAC4_0.DAC3_0.DAC2_1.sw_1.XM6.G.n2 DAC4_0.DAC3_0.DAC2_1.sw_1.XM6.G 9.3005
R5462 DAC4_0.DAC3_0.DAC2_1.sw_1.XM6.G.n1 DAC4_0.DAC3_0.DAC2_1.sw_1.XM6.G.n3 6.27093
R5463 DAC4_0.DAC3_0.DAC2_1.sw_1.XM6.G.n0 DAC4_0.DAC3_0.DAC2_1.sw_1.XM6.G.n4 5.39071
R5464 DAC4_0.DAC3_0.DAC2_1.sw_1.XM6.G.n4 DAC4_0.DAC3_0.DAC2_1.sw_1.XM6.G 4.7143
R5465 DAC4_0.DAC3_0.DAC2_1.sw_1.XM6.G.n3 DAC4_0.DAC3_0.DAC2_1.sw_1.XM6.G 4.68397
R5466 DAC4_0.DAC3_0.DAC2_1.sw_1.XM6.G.n0 DAC4_0.DAC3_0.DAC2_1.sw_1.XM6.G.n2 1.87089
R5467 DAC4_0.DAC3_0.DAC2_1.sw_1.XM6.G.n2 DAC4_0.DAC3_0.DAC2_1.sw_1.XM6.G.n1 1.47636
R5468 DAC4_0.DAC3_0.sw_0.XM6.G DAC4_0.DAC3_0.sw_0.XM6.G.t1 642.13
R5469 DAC4_0.DAC3_0.sw_0.XM6.G.t4 DAC4_0.DAC3_0.sw_0.XM6.G.n1 315.93
R5470 DAC4_0.DAC3_0.sw_0.XM6.G.n0 DAC4_0.DAC3_0.sw_0.XM6.G.t5 315.913
R5471 DAC4_0.DAC3_0.sw_0.XM6.G DAC4_0.DAC3_0.sw_0.XM6.G.t5 306.24
R5472 DAC4_0.DAC3_0.sw_0.XM6.G DAC4_0.DAC3_0.sw_0.XM6.G.t4 306.24
R5473 DAC4_0.DAC3_0.sw_0.XM6.G DAC4_0.DAC3_0.sw_0.XM6.G.t0 219.8
R5474 DAC4_0.DAC3_0.sw_0.XM6.G.n3 DAC4_0.DAC3_0.sw_0.XM6.G.t2 146.077
R5475 DAC4_0.DAC3_0.sw_0.XM6.G.n4 DAC4_0.DAC3_0.sw_0.XM6.G.t3 146.026
R5476 DAC4_0.DAC3_0.sw_0.XM6.G DAC4_0.DAC3_0.sw_0.XM6.G.n0 10.8091
R5477 DAC4_0.DAC3_0.sw_0.XM6.G.n0 DAC4_0.DAC3_0.sw_0.XM6.G 10.6655
R5478 DAC4_0.DAC3_0.sw_0.XM6.G.n2 DAC4_0.DAC3_0.sw_0.XM6.G 9.75229
R5479 DAC4_0.DAC3_0.sw_0.XM6.G.n2 DAC4_0.DAC3_0.sw_0.XM6.G 9.3005
R5480 DAC4_0.DAC3_0.sw_0.XM6.G.n1 DAC4_0.DAC3_0.sw_0.XM6.G.n3 6.27093
R5481 DAC4_0.DAC3_0.sw_0.XM6.G.n0 DAC4_0.DAC3_0.sw_0.XM6.G.n4 5.39071
R5482 DAC4_0.DAC3_0.sw_0.XM6.G.n4 DAC4_0.DAC3_0.sw_0.XM6.G 4.7143
R5483 DAC4_0.DAC3_0.sw_0.XM6.G.n3 DAC4_0.DAC3_0.sw_0.XM6.G 4.68397
R5484 DAC4_0.DAC3_0.sw_0.XM6.G.n0 DAC4_0.DAC3_0.sw_0.XM6.G.n2 1.87089
R5485 DAC4_0.DAC3_0.sw_0.XM6.G.n2 DAC4_0.DAC3_0.sw_0.XM6.G.n1 1.47636
R5486 DAC4_0.DAC3_0.DAC2_0.sw_0.XM6.G DAC4_0.DAC3_0.DAC2_0.sw_0.XM6.G.t1 642.13
R5487 DAC4_0.DAC3_0.DAC2_0.sw_0.XM6.G.t4 DAC4_0.DAC3_0.DAC2_0.sw_0.XM6.G.n1 315.93
R5488 DAC4_0.DAC3_0.DAC2_0.sw_0.XM6.G.n0 DAC4_0.DAC3_0.DAC2_0.sw_0.XM6.G.t5 315.913
R5489 DAC4_0.DAC3_0.DAC2_0.sw_0.XM6.G DAC4_0.DAC3_0.DAC2_0.sw_0.XM6.G.t5 306.24
R5490 DAC4_0.DAC3_0.DAC2_0.sw_0.XM6.G DAC4_0.DAC3_0.DAC2_0.sw_0.XM6.G.t4 306.24
R5491 DAC4_0.DAC3_0.DAC2_0.sw_0.XM6.G DAC4_0.DAC3_0.DAC2_0.sw_0.XM6.G.t0 219.8
R5492 DAC4_0.DAC3_0.DAC2_0.sw_0.XM6.G.n3 DAC4_0.DAC3_0.DAC2_0.sw_0.XM6.G.t2 146.077
R5493 DAC4_0.DAC3_0.DAC2_0.sw_0.XM6.G.n4 DAC4_0.DAC3_0.DAC2_0.sw_0.XM6.G.t3 146.026
R5494 DAC4_0.DAC3_0.DAC2_0.sw_0.XM6.G DAC4_0.DAC3_0.DAC2_0.sw_0.XM6.G.n0 10.8091
R5495 DAC4_0.DAC3_0.DAC2_0.sw_0.XM6.G.n0 DAC4_0.DAC3_0.DAC2_0.sw_0.XM6.G 10.6655
R5496 DAC4_0.DAC3_0.DAC2_0.sw_0.XM6.G.n2 DAC4_0.DAC3_0.DAC2_0.sw_0.XM6.G 9.75229
R5497 DAC4_0.DAC3_0.DAC2_0.sw_0.XM6.G.n2 DAC4_0.DAC3_0.DAC2_0.sw_0.XM6.G 9.3005
R5498 DAC4_0.DAC3_0.DAC2_0.sw_0.XM6.G.n1 DAC4_0.DAC3_0.DAC2_0.sw_0.XM6.G.n3 6.27093
R5499 DAC4_0.DAC3_0.DAC2_0.sw_0.XM6.G.n0 DAC4_0.DAC3_0.DAC2_0.sw_0.XM6.G.n4 5.39071
R5500 DAC4_0.DAC3_0.DAC2_0.sw_0.XM6.G.n4 DAC4_0.DAC3_0.DAC2_0.sw_0.XM6.G 4.7143
R5501 DAC4_0.DAC3_0.DAC2_0.sw_0.XM6.G.n3 DAC4_0.DAC3_0.DAC2_0.sw_0.XM6.G 4.68397
R5502 DAC4_0.DAC3_0.DAC2_0.sw_0.XM6.G.n0 DAC4_0.DAC3_0.DAC2_0.sw_0.XM6.G.n2 1.87089
R5503 DAC4_0.DAC3_0.DAC2_0.sw_0.XM6.G.n2 DAC4_0.DAC3_0.DAC2_0.sw_0.XM6.G.n1 1.47636
R5504 DAC4_0.DAC3_0.DAC2_0.sw_2.XM6.G DAC4_0.DAC3_0.DAC2_0.sw_2.XM6.G.t1 642.13
R5505 DAC4_0.DAC3_0.DAC2_0.sw_2.XM6.G.t4 DAC4_0.DAC3_0.DAC2_0.sw_2.XM6.G.n1 315.93
R5506 DAC4_0.DAC3_0.DAC2_0.sw_2.XM6.G.n0 DAC4_0.DAC3_0.DAC2_0.sw_2.XM6.G.t5 315.913
R5507 DAC4_0.DAC3_0.DAC2_0.sw_2.XM6.G DAC4_0.DAC3_0.DAC2_0.sw_2.XM6.G.t5 306.24
R5508 DAC4_0.DAC3_0.DAC2_0.sw_2.XM6.G DAC4_0.DAC3_0.DAC2_0.sw_2.XM6.G.t4 306.24
R5509 DAC4_0.DAC3_0.DAC2_0.sw_2.XM6.G DAC4_0.DAC3_0.DAC2_0.sw_2.XM6.G.t0 219.8
R5510 DAC4_0.DAC3_0.DAC2_0.sw_2.XM6.G.n3 DAC4_0.DAC3_0.DAC2_0.sw_2.XM6.G.t2 146.077
R5511 DAC4_0.DAC3_0.DAC2_0.sw_2.XM6.G.n4 DAC4_0.DAC3_0.DAC2_0.sw_2.XM6.G.t3 146.026
R5512 DAC4_0.DAC3_0.DAC2_0.sw_2.XM6.G DAC4_0.DAC3_0.DAC2_0.sw_2.XM6.G.n0 10.8091
R5513 DAC4_0.DAC3_0.DAC2_0.sw_2.XM6.G.n0 DAC4_0.DAC3_0.DAC2_0.sw_2.XM6.G 10.6655
R5514 DAC4_0.DAC3_0.DAC2_0.sw_2.XM6.G.n2 DAC4_0.DAC3_0.DAC2_0.sw_2.XM6.G 9.75229
R5515 DAC4_0.DAC3_0.DAC2_0.sw_2.XM6.G.n2 DAC4_0.DAC3_0.DAC2_0.sw_2.XM6.G 9.3005
R5516 DAC4_0.DAC3_0.DAC2_0.sw_2.XM6.G.n1 DAC4_0.DAC3_0.DAC2_0.sw_2.XM6.G.n3 6.27093
R5517 DAC4_0.DAC3_0.DAC2_0.sw_2.XM6.G.n0 DAC4_0.DAC3_0.DAC2_0.sw_2.XM6.G.n4 5.39071
R5518 DAC4_0.DAC3_0.DAC2_0.sw_2.XM6.G.n4 DAC4_0.DAC3_0.DAC2_0.sw_2.XM6.G 4.7143
R5519 DAC4_0.DAC3_0.DAC2_0.sw_2.XM6.G.n3 DAC4_0.DAC3_0.DAC2_0.sw_2.XM6.G 4.68397
R5520 DAC4_0.DAC3_0.DAC2_0.sw_2.XM6.G.n0 DAC4_0.DAC3_0.DAC2_0.sw_2.XM6.G.n2 1.87089
R5521 DAC4_0.DAC3_0.DAC2_0.sw_2.XM6.G.n2 DAC4_0.DAC3_0.DAC2_0.sw_2.XM6.G.n1 1.47636
R5522 DAC4_0.DAC3_0.DAC2_0.sw_1.XM6.G DAC4_0.DAC3_0.DAC2_0.sw_1.XM6.G.t1 642.13
R5523 DAC4_0.DAC3_0.DAC2_0.sw_1.XM6.G.t4 DAC4_0.DAC3_0.DAC2_0.sw_1.XM6.G.n1 315.93
R5524 DAC4_0.DAC3_0.DAC2_0.sw_1.XM6.G.n0 DAC4_0.DAC3_0.DAC2_0.sw_1.XM6.G.t5 315.913
R5525 DAC4_0.DAC3_0.DAC2_0.sw_1.XM6.G DAC4_0.DAC3_0.DAC2_0.sw_1.XM6.G.t5 306.24
R5526 DAC4_0.DAC3_0.DAC2_0.sw_1.XM6.G DAC4_0.DAC3_0.DAC2_0.sw_1.XM6.G.t4 306.24
R5527 DAC4_0.DAC3_0.DAC2_0.sw_1.XM6.G DAC4_0.DAC3_0.DAC2_0.sw_1.XM6.G.t0 219.8
R5528 DAC4_0.DAC3_0.DAC2_0.sw_1.XM6.G.n3 DAC4_0.DAC3_0.DAC2_0.sw_1.XM6.G.t2 146.077
R5529 DAC4_0.DAC3_0.DAC2_0.sw_1.XM6.G.n4 DAC4_0.DAC3_0.DAC2_0.sw_1.XM6.G.t3 146.026
R5530 DAC4_0.DAC3_0.DAC2_0.sw_1.XM6.G DAC4_0.DAC3_0.DAC2_0.sw_1.XM6.G.n0 10.8091
R5531 DAC4_0.DAC3_0.DAC2_0.sw_1.XM6.G.n0 DAC4_0.DAC3_0.DAC2_0.sw_1.XM6.G 10.6655
R5532 DAC4_0.DAC3_0.DAC2_0.sw_1.XM6.G.n2 DAC4_0.DAC3_0.DAC2_0.sw_1.XM6.G 9.75229
R5533 DAC4_0.DAC3_0.DAC2_0.sw_1.XM6.G.n2 DAC4_0.DAC3_0.DAC2_0.sw_1.XM6.G 9.3005
R5534 DAC4_0.DAC3_0.DAC2_0.sw_1.XM6.G.n1 DAC4_0.DAC3_0.DAC2_0.sw_1.XM6.G.n3 6.27093
R5535 DAC4_0.DAC3_0.DAC2_0.sw_1.XM6.G.n0 DAC4_0.DAC3_0.DAC2_0.sw_1.XM6.G.n4 5.39071
R5536 DAC4_0.DAC3_0.DAC2_0.sw_1.XM6.G.n4 DAC4_0.DAC3_0.DAC2_0.sw_1.XM6.G 4.7143
R5537 DAC4_0.DAC3_0.DAC2_0.sw_1.XM6.G.n3 DAC4_0.DAC3_0.DAC2_0.sw_1.XM6.G 4.68397
R5538 DAC4_0.DAC3_0.DAC2_0.sw_1.XM6.G.n0 DAC4_0.DAC3_0.DAC2_0.sw_1.XM6.G.n2 1.87089
R5539 DAC4_0.DAC3_0.DAC2_0.sw_1.XM6.G.n2 DAC4_0.DAC3_0.DAC2_0.sw_1.XM6.G.n1 1.47636
C0 DAC4_0.DAC3_1.vrefh DAC4_0.DAC3_0.DAC2_1.sw_1.vin1 0
C1 DAC4_0.DAC3_0.DAC2_0.sw_0.XM8.G DAC4_0.DAC3_0.DAC2_1.sw_1.vin1 0
C2 DAC4_0.sw_0.XM8.G avdd 0.57342f
C3 DAC4_1.sw_0.XM6.G DAC4_1.DAC3_0.DAC2_1.sw_2.vin1 0
C4 DAC4_1.DAC3_0.DAC2_1.sw_1.XM6.G DAC4_1.DAC3_0.DAC2_1.sw_2.vin2 0
C5 DAC4_1.DAC3_0.DAC2_1.sw_2.vin2 DAC4_1.DAC3_0.sw_0.vin2 0.22107f
C6 DAC4_1.DAC3_0.DAC2_0.sw_0.XM8.G li_11369_1922# 0
C7 avdd DAC4_1.DAC3_0.sw_0.XM8.G 0.56426f
C8 b1 DAC4_0.DAC3_1.sw_0.vin1 0.04316f
C9 DAC4_1.sw_0.vin1 DAC4_1.DAC3_0.DAC2_1.sw_0.XM8.G 0
C10 DAC4_1.DAC3_1.DAC2_1.sw_2.vin2 DAC4_1.DAC3_1.DAC2_1.sw_2.vin1 0.18111f
C11 b0 li_6_997# 0.05804f
C12 DAC4_1.DAC3_0.sw_0.vin1 DAC4_1.DAC3_0.sw_0.XM8.G 0.26095f
C13 DAC4_0.DAC3_1.DAC2_0.sw_2.XM6.G DAC4_0.sw_0.XM6.G 0
C14 sw_0.XM6.G vout 0.11006f
C15 DAC4_0.DAC3_0.DAC2_1.sw_2.vin1 avdd 0.75747f
C16 DAC4_0.DAC3_1.DAC2_1.sw_2.XM8.G DAC4_0.DAC3_1.DAC2_1.sw_0.XM8.G 0
C17 DAC4_1.DAC3_1.DAC2_1.sw_1.XM6.G DAC4_1.DAC3_1.DAC2_0.sw_0.XM6.G 0
C18 DAC4_0.DAC3_0.DAC2_0.sw_2.XM8.G DAC4_0.DAC3_0.sw_0.XM8.G 0
C19 DAC4_1.DAC3_0.DAC2_1.sw_2.XM8.G DAC4_1.DAC3_0.DAC2_1.sw_2.vin2 0.20378f
C20 DAC4_0.sw_0.vin1 DAC4_0.DAC3_1.DAC2_0.sw_2.XM8.G 0
C21 sw_0.XM6.G DAC4_1.sw_0.vin2 0
C22 DAC4_0.DAC3_1.DAC2_0.sw_2.vin2 DAC4_0.DAC3_1.DAC2_0.sw_1.XM6.G 0
C23 b1 DAC4_1.DAC3_0.DAC2_1.sw_1.vin1 0.00152f
C24 DAC4_1.DAC3_1.DAC2_0.sw_2.vin2 li_11371_9136# 0
C25 DAC4_1.DAC3_1.DAC2_1.sw_0.XM8.G DAC4_1.DAC3_1.DAC2_1.sw_0.vin1 0.2606f
C26 DAC4_0.DAC3_0.DAC2_0.sw_0.vin1 DAC4_0.DAC3_0.DAC2_0.sw_1.vin1 0.00795f
C27 DAC4_0.DAC3_1.sw_0.XM6.G DAC4_0.sw_0.vin2 0.1101f
C28 avdd li_6_4623# 0.47589f
C29 vout b4 0
C30 DAC4_1.DAC3_1.DAC2_0.sw_1.XM6.G DAC4_1.DAC3_1.DAC2_1.vrefh 0.00122f
C31 DAC4_0.DAC3_1.sw_0.vin1 DAC4_0.sw_0.XM6.G 0
C32 DAC4_1.sw_0.vin2 b4 0
C33 sw_0.vin1 DAC4_1.DAC3_1.DAC2_0.sw_2.vin2 0
C34 DAC4_0.DAC3_0.sw_0.vin1 DAC4_0.DAC3_0.sw_0.XM6.G 0.30206f
C35 avdd DAC4_0.DAC3_1.DAC2_0.sw_2.vin1 0.77113f
C36 DAC4_0.DAC3_1.DAC2_0.sw_2.XM6.G b3 0.00239f
C37 DAC4_1.DAC3_0.DAC2_1.sw_1.XM6.G DAC4_1.DAC3_0.DAC2_0.sw_0.XM6.G 0
C38 DAC4_1.vrefh b2 0.05424f
C39 DAC4_0.DAC3_1.DAC2_1.sw_0.XM6.G DAC4_0.DAC3_1.DAC2_1.sw_0.vin1 0.30012f
C40 DAC4_1.DAC3_0.DAC2_0.sw_1.XM6.G DAC4_1.DAC3_0.DAC2_1.vrefh 0.00122f
C41 DAC4_1.sw_0.vin1 DAC4_1.DAC3_0.DAC2_1.sw_2.vin2 0.00396f
C42 DAC4_1.DAC3_1.DAC2_1.sw_2.vin2 DAC4_1.DAC3_1.DAC2_1.sw_1.XM8.G 0
C43 b1 DAC4_1.DAC3_1.DAC2_0.sw_1.XM6.G 0
C44 li_8_8211# avdd 0.4768f
C45 b1 DAC4_0.DAC3_0.DAC2_1.sw_0.XM8.G 0.00175f
C46 DAC4_0.DAC3_0.DAC2_1.vrefh DAC4_0.DAC3_0.DAC2_1.sw_1.XM6.G 0
C47 DAC4_1.DAC3_0.DAC2_1.sw_0.XM6.G DAC4_1.DAC3_1.vrefh 0.40159f
C48 b0 DAC4_1.DAC3_0.DAC2_1.sw_0.XM6.G 0.12588f
C49 DAC4_0.DAC3_0.DAC2_1.sw_1.XM6.G DAC4_0.DAC3_0.DAC2_1.sw_1.XM8.G 0.33977f
C50 vrefl DAC4_1.DAC3_1.DAC2_1.sw_1.XM6.G 0.00122f
C51 DAC4_0.DAC3_1.sw_0.vin1 b3 0.00403f
C52 DAC4_0.DAC3_1.DAC2_0.sw_0.vin1 li_6_4623# 0.02024f
C53 DAC4_1.DAC3_0.sw_0.XM8.G DAC4_1.DAC3_0.sw_0.vin2 0.20441f
C54 DAC4_0.DAC3_0.sw_0.vin2 avdd 0.91769f
C55 DAC4_1.DAC3_0.DAC2_0.sw_0.XM8.G b0 0
C56 DAC4_0.DAC3_0.DAC2_1.vrefh DAC4_0.DAC3_0.DAC2_0.sw_0.XM8.G 0.20379f
C57 b2 DAC4_1.DAC3_0.DAC2_1.sw_2.vin1 0.21786f
C58 DAC4_0.DAC3_0.DAC2_0.sw_0.XM8.G DAC4_0.DAC3_0.DAC2_1.sw_1.XM8.G 0
C59 b1 DAC4_0.DAC3_1.DAC2_1.sw_2.vin2 0.3834f
C60 b0 DAC4_0.DAC3_1.DAC2_1.sw_1.XM6.G 0.12643f
C61 DAC4_0.DAC3_1.vrefh DAC4_0.DAC3_0.DAC2_1.sw_1.XM8.G 0.0014f
C62 DAC4_1.DAC3_0.DAC2_0.sw_2.vin2 DAC4_1.DAC3_0.DAC2_1.sw_1.XM8.G 0
C63 b0 DAC4_1.DAC3_1.DAC2_1.sw_1.vin1 0.35812f
C64 DAC4_0.DAC3_1.DAC2_1.sw_1.vin2 b0 0.29783f
C65 DAC4_1.DAC3_1.DAC2_1.sw_1.XM6.G DAC4_1.DAC3_1.DAC2_1.sw_0.XM6.G 0.00169f
C66 DAC4_1.DAC3_0.DAC2_1.sw_2.XM8.G DAC4_1.DAC3_0.sw_0.XM8.G 0
C67 DAC4_0.sw_0.vin1 DAC4_0.DAC3_0.sw_0.XM6.G 0.11007f
C68 DAC4_0.DAC3_1.DAC2_0.sw_2.vin2 b2 0.39869f
C69 b1 DAC4_0.DAC3_1.DAC2_0.sw_2.XM8.G 0
C70 b0 DAC4_1.DAC3_1.DAC2_1.sw_1.vin2 0.29685f
C71 DAC4_0.DAC3_1.DAC2_0.sw_1.XM6.G DAC4_0.DAC3_1.vrefh 0
C72 b1 DAC4_0.DAC3_1.DAC2_0.sw_0.XM6.G 0
C73 b0 li_6_5533# 0.02486f
C74 DAC4_0.DAC3_0.DAC2_0.sw_1.XM6.G li_8_12747# 0
C75 DAC4_0.DAC3_0.DAC2_1.sw_1.vin2 avdd 0.57892f
C76 DAC4_1.DAC3_0.DAC2_1.sw_0.XM8.G DAC4_1.DAC3_0.DAC2_1.sw_2.vin1 0
C77 b1 DAC4_1.DAC3_0.DAC2_1.sw_1.XM8.G 0.00287f
C78 DAC4_1.sw_0.vin1 b4 0
C79 DAC4_1.DAC3_1.DAC2_0.sw_2.vin2 DAC4_1.sw_0.XM8.G 0
C80 DAC4_0.DAC3_0.DAC2_0.sw_0.XM6.G DAC4_0.DAC3_0.DAC2_1.sw_1.vin1 0
C81 b0 DAC4_0.DAC3_1.DAC2_1.sw_1.vin1 0.35812f
C82 sw_0.XM6.G sw_0.vin2 0.40158f
C83 b0 DAC4_0.DAC3_1.DAC2_0.sw_1.vin1 0.35806f
C84 DAC4_1.DAC3_1.DAC2_0.sw_1.XM6.G DAC4_1.DAC3_1.DAC2_0.sw_2.vin1 0.11006f
C85 DAC4_0.DAC3_0.DAC2_0.sw_0.vin1 DAC4_0.DAC3_0.DAC2_0.sw_1.XM8.G 0
C86 DAC4_1.sw_0.XM6.G DAC4_1.sw_0.XM8.G 0.33977f
C87 DAC4_0.DAC3_0.DAC2_1.vrefh DAC4_0.DAC3_0.DAC2_0.sw_2.vin2 0.20906f
C88 DAC4_0.DAC3_0.sw_0.vin2 vout 0
C89 DAC4_0.DAC3_0.DAC2_1.sw_1.XM8.G DAC4_0.DAC3_0.DAC2_0.sw_2.vin2 0
C90 DAC4_1.sw_0.vin1 DAC4_1.DAC3_0.sw_0.XM8.G 0.45195f
C91 b0 DAC4_1.DAC3_1.DAC2_1.sw_2.vin1 0
C92 DAC4_0.DAC3_1.DAC2_0.sw_2.XM8.G DAC4_0.sw_0.XM6.G 0
C93 b1 DAC4_0.DAC3_0.DAC2_0.sw_0.vin1 0.01304f
C94 DAC4_1.DAC3_1.DAC2_0.sw_1.vin1 DAC4_1.DAC3_1.DAC2_0.sw_1.XM6.G 0.30012f
C95 DAC4_1.DAC3_1.DAC2_1.sw_2.vin2 DAC4_1.DAC3_1.sw_0.XM6.G 0
C96 DAC4_1.DAC3_1.DAC2_1.sw_0.XM8.G vrefl 0.20379f
C97 avdd DAC4_0.DAC3_1.DAC2_0.sw_1.vin2 0.58035f
C98 DAC4_1.DAC3_1.DAC2_1.sw_1.XM6.G DAC4_1.DAC3_1.DAC2_1.vrefh 0
C99 DAC4_0.DAC3_1.DAC2_1.sw_2.XM6.G DAC4_0.DAC3_1.DAC2_1.sw_0.XM8.G 0
C100 DAC4_0.DAC3_0.DAC2_0.sw_2.XM8.G DAC4_0.DAC3_0.sw_0.XM6.G 0
C101 DAC4_1.DAC3_1.sw_0.XM8.G DAC4_1.DAC3_1.sw_0.vin1 0.26095f
C102 sw_0.vin2 b4 0.12852f
C103 DAC4_0.DAC3_1.DAC2_1.sw_0.XM6.G DAC4_0.DAC3_1.DAC2_1.sw_0.XM8.G 0.33977f
C104 b1 DAC4_1.DAC3_0.DAC2_0.sw_1.vin2 0
C105 DAC4_0.sw_0.XM8.G sw_0.vin2 0
C106 li_11369_1012# DAC4_1.DAC3_0.DAC2_0.sw_1.XM8.G 0
C107 DAC4_1.DAC3_1.DAC2_1.sw_0.XM8.G DAC4_1.DAC3_1.DAC2_1.sw_0.XM6.G 0.33977f
C108 DAC4_1.DAC3_0.DAC2_1.sw_2.vin2 DAC4_1.DAC3_0.DAC2_1.sw_2.vin1 0.18111f
C109 DAC4_1.DAC3_1.DAC2_0.sw_1.vin2 li_11371_8226# 0.02113f
C110 DAC4_0.DAC3_1.DAC2_1.sw_1.XM6.G DAC4_0.DAC3_1.DAC2_0.sw_0.XM8.G 0
C111 li_11369_1012# avdd 0.44111f
C112 DAC4_1.DAC3_0.DAC2_0.sw_2.vin1 DAC4_1.DAC3_0.DAC2_0.sw_1.vin2 0.19197f
C113 DAC4_0.DAC3_1.DAC2_1.sw_1.vin2 DAC4_0.DAC3_1.DAC2_0.sw_0.XM8.G 0
C114 b0 li_11369_2832# 0.01165f
C115 b1 DAC4_1.DAC3_1.DAC2_1.sw_1.XM6.G 0.00135f
C116 DAC4_0.DAC3_0.DAC2_1.sw_1.XM6.G b2 0.00219f
C117 DAC4_1.DAC3_0.DAC2_0.sw_2.XM8.G DAC4_1.DAC3_0.DAC2_0.sw_1.XM8.G 0
C118 DAC4_0.DAC3_1.DAC2_0.sw_2.XM8.G b3 0
C119 b1 DAC4_0.DAC3_1.DAC2_1.sw_2.XM8.G 0.00439f
C120 DAC4_0.DAC3_1.DAC2_1.sw_0.XM8.G DAC4_0.DAC3_1.DAC2_1.sw_0.vin1 0.2606f
C121 DAC4_0.DAC3_0.DAC2_1.sw_2.vin1 sw_0.vin2 0
C122 DAC4_0.DAC3_0.DAC2_0.sw_2.vin1 DAC4_0.DAC3_0.DAC2_0.sw_0.XM8.G 0
C123 b1 DAC4_0.DAC3_0.sw_0.XM6.G 0
C124 DAC4_1.DAC3_0.DAC2_0.sw_2.XM8.G avdd 0.57051f
C125 DAC4_0.DAC3_0.DAC2_0.sw_1.vin1 li_8_13657# 0
C126 b0 DAC4_1.DAC3_1.DAC2_1.sw_1.XM8.G 0
C127 b0 DAC4_1.DAC3_1.DAC2_0.sw_0.vin1 0.50703f
C128 DAC4_0.DAC3_1.vrefh b2 0.02548f
C129 DAC4_0.DAC3_0.DAC2_0.sw_1.XM6.G avdd 1.05416f
C130 b0 DAC4_0.DAC3_0.DAC2_1.sw_2.vin2 0
C131 DAC4_0.DAC3_1.DAC2_0.sw_0.vin1 DAC4_0.DAC3_1.DAC2_0.sw_1.vin2 0.02132f
C132 DAC4_1.DAC3_0.DAC2_1.sw_1.vin1 DAC4_1.DAC3_0.DAC2_1.sw_0.XM6.G 0
C133 DAC4_1.DAC3_0.DAC2_1.sw_1.vin2 DAC4_1.DAC3_1.vrefh 0.01211f
C134 DAC4_0.DAC3_1.DAC2_1.sw_2.vin2 li_6_997# 0
C135 DAC4_1.DAC3_0.DAC2_0.sw_2.XM8.G DAC4_1.DAC3_0.sw_0.vin1 0.45396f
C136 b0 DAC4_1.DAC3_0.DAC2_1.sw_1.vin2 0.2977f
C137 DAC4_0.DAC3_1.DAC2_1.sw_1.vin1 DAC4_0.DAC3_1.DAC2_0.sw_0.XM8.G 0
C138 b1 DAC4_0.DAC3_0.DAC2_1.sw_0.XM6.G 0
C139 avdd li_6_2817# 0.47745f
C140 DAC4_0.DAC3_1.DAC2_0.sw_1.vin1 DAC4_0.DAC3_1.DAC2_0.sw_0.XM8.G 0
C141 b0 DAC4_1.DAC3_0.DAC2_0.sw_1.vin1 0.3865f
C142 DAC4_1.DAC3_0.DAC2_0.sw_0.XM8.G DAC4_1.DAC3_0.DAC2_1.sw_1.vin1 0
C143 DAC4_0.DAC3_0.DAC2_1.vrefh DAC4_0.DAC3_0.DAC2_0.sw_0.XM6.G 0.40159f
C144 b0 DAC4_0.DAC3_1.DAC2_1.sw_1.XM8.G 0
C145 li_8_12747# avdd 0.44111f
C146 b0 DAC4_0.DAC3_1.DAC2_0.sw_1.XM8.G 0
C147 li_8_7301# avdd 0.43318f
C148 DAC4_0.DAC3_0.DAC2_0.sw_2.vin1 DAC4_0.DAC3_0.DAC2_0.sw_2.vin2 0.18111f
C149 DAC4_1.DAC3_1.sw_0.vin1 DAC4_1.DAC3_1.DAC2_0.sw_2.XM6.G 0.11216f
C150 b2 DAC4_0.DAC3_0.DAC2_0.sw_2.vin2 0.0015f
C151 b0 DAC4_0.DAC3_0.DAC2_1.sw_1.vin1 0.35813f
C152 DAC4_1.DAC3_1.sw_0.vin1 DAC4_1.DAC3_1.DAC2_0.sw_2.XM8.G 0.45396f
C153 DAC4_1.DAC3_0.DAC2_1.sw_0.XM6.G DAC4_1.DAC3_1.DAC2_0.sw_1.XM6.G 0
C154 DAC4_1.DAC3_1.DAC2_1.sw_0.XM8.G b1 0
C155 DAC4_0.DAC3_0.sw_0.vin2 sw_0.vin2 0.00291f
C156 DAC4_1.DAC3_1.DAC2_0.sw_1.XM8.G avdd 0.57659f
C157 b0 DAC4_0.DAC3_1.sw_0.vin2 0
C158 DAC4_1.DAC3_0.DAC2_0.sw_2.vin2 DAC4_1.DAC3_0.DAC2_0.sw_1.XM6.G 0
C159 DAC4_0.DAC3_1.DAC2_1.sw_2.vin1 b0 0
C160 b1 DAC4_0.DAC3_1.DAC2_1.vrefh 0
C161 DAC4_0.DAC3_0.DAC2_1.sw_0.vin1 DAC4_0.DAC3_0.DAC2_1.sw_2.vin2 0.27806f
C162 sw_0.XM6.G sw_0.vin1 0.30015f
C163 DAC4_1.DAC3_0.DAC2_0.sw_2.XM8.G DAC4_1.DAC3_0.sw_0.vin2 0
C164 DAC4_0.DAC3_0.sw_0.vin1 DAC4_0.DAC3_0.DAC2_0.sw_2.XM6.G 0.11216f
C165 b0 li_11371_7316# 0.01691f
C166 DAC4_0.DAC3_1.DAC2_1.sw_2.vin2 DAC4_0.DAC3_1.DAC2_1.sw_1.XM6.G 0
C167 DAC4_1.DAC3_0.DAC2_0.sw_2.XM6.G DAC4_1.DAC3_0.sw_0.XM6.G 0
C168 DAC4_0.sw_0.vin1 DAC4_0.sw_0.vin2 0.18495f
C169 b1 DAC4_0.DAC3_1.sw_0.XM6.G 0
C170 b1 DAC4_1.DAC3_0.DAC2_0.sw_1.XM6.G 0
C171 sw_0.vin1 b4 0.1584f
C172 b0 DAC4_1.DAC3_1.DAC2_0.sw_0.XM8.G 0
C173 DAC4_0.DAC3_1.DAC2_0.sw_1.XM8.G DAC4_0.DAC3_0.DAC2_1.sw_0.vin1 0
C174 DAC4_0.DAC3_1.DAC2_0.sw_1.vin1 DAC4_0.DAC3_0.DAC2_1.sw_0.XM8.G 0
C175 DAC4_1.DAC3_0.DAC2_1.sw_1.XM8.G DAC4_1.DAC3_0.DAC2_1.sw_0.XM6.G 0
C176 DAC4_0.DAC3_1.DAC2_0.sw_2.vin2 li_6_4623# 0
C177 DAC4_0.DAC3_1.DAC2_1.sw_1.XM8.G DAC4_0.DAC3_1.DAC2_0.sw_0.XM8.G 0
C178 DAC4_0.sw_0.XM8.G sw_0.vin1 0.45192f
C179 DAC4_0.DAC3_1.DAC2_1.sw_1.XM6.G DAC4_0.DAC3_1.DAC2_0.sw_0.XM6.G 0
C180 avdd DAC4_1.DAC3_0.DAC2_0.sw_1.XM8.G 0.57719f
C181 DAC4_0.DAC3_1.DAC2_0.sw_1.XM8.G DAC4_0.DAC3_1.DAC2_0.sw_2.XM6.G 0
C182 DAC4_1.DAC3_0.DAC2_0.sw_2.vin1 DAC4_1.DAC3_0.DAC2_0.sw_1.XM6.G 0.11006f
C183 DAC4_0.DAC3_1.DAC2_0.sw_1.XM8.G DAC4_0.DAC3_1.DAC2_0.sw_0.XM8.G 0
C184 DAC4_0.DAC3_1.DAC2_1.sw_1.vin2 DAC4_0.DAC3_1.DAC2_0.sw_0.XM6.G 0
C185 DAC4_1.DAC3_0.DAC2_0.sw_0.XM8.G DAC4_1.DAC3_0.DAC2_1.sw_1.XM8.G 0
C186 DAC4_1.DAC3_1.DAC2_1.sw_0.XM8.G DAC4_1.DAC3_1.DAC2_1.sw_2.XM6.G 0
C187 DAC4_1.DAC3_1.DAC2_1.sw_0.vin1 vrefl 0.19364f
C188 DAC4_1.DAC3_1.DAC2_0.sw_1.vin2 DAC4_1.DAC3_1.vrefh 0.00556f
C189 DAC4_0.DAC3_0.DAC2_1.sw_0.vin1 DAC4_0.DAC3_0.DAC2_1.sw_1.vin1 0.00795f
C190 b0 DAC4_1.DAC3_1.DAC2_0.sw_1.vin2 0.29748f
C191 DAC4_1.DAC3_1.DAC2_0.sw_1.XM8.G DAC4_1.sw_0.vin2 0
C192 DAC4_1.DAC3_1.DAC2_1.sw_2.vin2 b2 0
C193 DAC4_0.DAC3_1.DAC2_0.sw_2.vin2 DAC4_0.DAC3_1.DAC2_0.sw_2.vin1 0.18091f
C194 b1 DAC4_0.DAC3_1.DAC2_1.sw_2.XM6.G 0.1331f
C195 DAC4_1.DAC3_0.sw_0.vin1 avdd 1.69018f
C196 DAC4_0.DAC3_0.DAC2_0.sw_2.vin1 DAC4_0.DAC3_0.DAC2_0.sw_0.XM6.G 0
C197 b1 DAC4_0.DAC3_1.DAC2_1.sw_0.XM6.G 0
C198 DAC4_1.DAC3_0.DAC2_1.sw_1.vin2 DAC4_1.DAC3_0.DAC2_1.sw_1.vin1 0.18076f
C199 DAC4_1.DAC3_0.DAC2_0.sw_2.XM8.G DAC4_1.sw_0.vin1 0
C200 DAC4_1.DAC3_1.DAC2_1.sw_0.vin1 DAC4_1.DAC3_1.DAC2_1.sw_0.XM6.G 0.30012f
C201 DAC4_0.DAC3_1.DAC2_1.sw_1.vin1 DAC4_0.DAC3_1.DAC2_0.sw_0.XM6.G 0
C202 DAC4_0.DAC3_1.DAC2_0.sw_2.XM6.G DAC4_0.DAC3_1.sw_0.vin2 0
C203 b0 li_6_87# 0.06601f
C204 DAC4_0.DAC3_1.DAC2_0.sw_1.vin1 DAC4_0.DAC3_1.DAC2_0.sw_0.XM6.G 0
C205 b1 DAC4_1.DAC3_1.sw_0.vin1 0.04316f
C206 DAC4_1.DAC3_1.sw_0.XM8.G DAC4_1.DAC3_1.DAC2_0.sw_2.XM6.G 0
C207 DAC4_1.DAC3_1.sw_0.XM8.G DAC4_1.DAC3_1.DAC2_0.sw_2.XM8.G 0
C208 b0 DAC4_0.DAC3_0.DAC2_1.vrefh 0.54824f
C209 b0 DAC4_0.DAC3_0.DAC2_1.sw_1.XM8.G 0
C210 b0 DAC4_1.DAC3_1.DAC2_0.sw_2.vin2 0
C211 DAC4_0.DAC3_1.DAC2_1.sw_2.vin1 DAC4_0.DAC3_1.DAC2_0.sw_0.XM8.G 0
C212 sw_0.XM6.G DAC4_1.sw_0.XM8.G 0
C213 DAC4_0.DAC3_1.DAC2_0.sw_0.vin1 avdd 0.71993f
C214 DAC4_0.DAC3_0.DAC2_1.sw_2.vin1 DAC4_0.DAC3_0.DAC2_1.sw_1.XM6.G 0.11006f
C215 b1 DAC4_0.DAC3_1.DAC2_1.sw_0.vin1 0
C216 DAC4_0.DAC3_0.DAC2_1.sw_2.vin2 DAC4_0.DAC3_0.sw_0.XM8.G 0
C217 DAC4_1.DAC3_1.DAC2_0.sw_1.XM6.G DAC4_1.DAC3_1.DAC2_0.sw_0.vin1 0.00197f
C218 b0 DAC4_0.DAC3_1.DAC2_0.sw_1.XM6.G 0.12643f
C219 avdd vout 0.2024f
C220 DAC4_1.DAC3_0.DAC2_0.sw_2.vin2 DAC4_1.DAC3_0.DAC2_1.vrefh 0.20479f
C221 avdd li_11369_4638# 0.44052f
C222 DAC4_1.sw_0.XM8.G b4 0
C223 DAC4_0.DAC3_0.DAC2_1.sw_0.XM8.G DAC4_0.DAC3_0.DAC2_1.sw_2.vin2 0.46313f
C224 DAC4_0.DAC3_0.DAC2_0.sw_0.XM8.G DAC4_0.DAC3_0.DAC2_1.sw_2.vin1 0
C225 DAC4_0.DAC3_0.DAC2_1.sw_2.vin1 DAC4_0.DAC3_1.vrefh 0.01454f
C226 DAC4_0.DAC3_1.sw_0.vin1 DAC4_0.DAC3_1.sw_0.vin2 0.20354f
C227 avdd DAC4_1.sw_0.vin2 1.10451f
C228 vrefl li_11371_13672# 0.12591f
C229 DAC4_0.DAC3_1.DAC2_1.sw_2.vin1 DAC4_0.DAC3_1.sw_0.vin1 0
C230 DAC4_1.DAC3_1.vrefh DAC4_1.DAC3_0.DAC2_1.sw_0.vin1 0.19196f
C231 b1 DAC4_0.sw_0.vin2 0.00456f
C232 DAC4_1.DAC3_1.DAC2_1.sw_1.vin1 DAC4_1.DAC3_1.DAC2_1.sw_1.XM6.G 0.30012f
C233 b0 DAC4_1.DAC3_0.DAC2_1.sw_0.vin1 0.50813f
C234 DAC4_0.DAC3_0.DAC2_0.sw_2.XM8.G DAC4_0.DAC3_0.DAC2_0.sw_2.XM6.G 0.33977f
C235 DAC4_1.DAC3_1.DAC2_1.sw_1.XM6.G DAC4_1.DAC3_1.DAC2_1.sw_1.vin2 0.40155f
C236 DAC4_1.DAC3_0.DAC2_1.sw_1.XM6.G avdd 1.05416f
C237 avdd DAC4_1.DAC3_0.sw_0.vin2 0.91034f
C238 li_8_11837# avdd 0.47589f
C239 b1 DAC4_1.DAC3_0.DAC2_1.vrefh 0
C240 DAC4_0.DAC3_1.DAC2_0.sw_1.XM8.G DAC4_0.DAC3_0.DAC2_1.sw_0.XM8.G 0
C241 DAC4_1.DAC3_0.DAC2_0.sw_2.XM8.G DAC4_1.vrefh 0
C242 DAC4_1.DAC3_0.sw_0.vin1 DAC4_1.DAC3_0.sw_0.vin2 0.20354f
C243 DAC4_1.DAC3_0.DAC2_0.sw_2.vin2 DAC4_1.DAC3_0.sw_0.XM6.G 0
C244 DAC4_1.DAC3_1.sw_0.vin1 DAC4_1.DAC3_1.DAC2_1.sw_2.XM6.G 0
C245 DAC4_0.DAC3_0.DAC2_0.sw_1.XM8.G DAC4_0.DAC3_0.DAC2_0.sw_2.XM6.G 0
C246 DAC4_0.DAC3_0.sw_0.vin1 DAC4_0.sw_0.vin1 0.25821f
C247 DAC4_1.DAC3_1.sw_0.vin1 DAC4_1.DAC3_1.DAC2_0.sw_2.vin1 0.26064f
C248 DAC4_1.DAC3_0.DAC2_1.sw_2.XM8.G avdd 0.56431f
C249 DAC4_1.DAC3_0.DAC2_0.sw_2.vin1 DAC4_1.DAC3_0.DAC2_1.vrefh 0.01454f
C250 DAC4_0.DAC3_0.DAC2_1.sw_0.XM8.G DAC4_0.DAC3_0.DAC2_1.sw_1.vin1 0
C251 DAC4_1.DAC3_1.DAC2_1.sw_0.vin1 b1 0
C252 DAC4_0.DAC3_0.DAC2_1.sw_0.vin1 DAC4_0.DAC3_0.DAC2_1.sw_1.XM8.G 0
C253 DAC4_0.DAC3_1.DAC2_1.sw_2.vin2 DAC4_0.DAC3_1.DAC2_1.sw_1.XM8.G 0
C254 DAC4_0.sw_0.XM6.G DAC4_0.sw_0.vin2 0.4025f
C255 b1 DAC4_0.DAC3_0.DAC2_0.sw_2.XM6.G 0.12571f
C256 li_8_8211# DAC4_0.DAC3_1.vrefh 0
C257 DAC4_0.DAC3_0.DAC2_0.sw_1.vin2 DAC4_0.DAC3_0.DAC2_0.sw_0.XM6.G 0
C258 DAC4_1.DAC3_1.sw_0.vin1 DAC4_1.DAC3_1.sw_0.vin2 0.20354f
C259 DAC4_1.DAC3_0.DAC2_1.sw_2.XM8.G DAC4_1.DAC3_0.sw_0.vin1 0
C260 DAC4_1.DAC3_1.DAC2_1.sw_1.XM6.G DAC4_1.DAC3_1.DAC2_1.sw_2.vin1 0.11006f
C261 DAC4_1.sw_0.vin2 vout 0.00376f
C262 DAC4_1.DAC3_0.DAC2_1.sw_1.vin2 DAC4_1.DAC3_0.DAC2_1.sw_1.XM8.G 0.20368f
C263 b1 DAC4_1.DAC3_0.sw_0.XM6.G 0
C264 DAC4_1.DAC3_1.DAC2_0.sw_2.XM8.G DAC4_1.DAC3_1.DAC2_0.sw_2.XM6.G 0.33977f
C265 DAC4_1.DAC3_0.DAC2_0.sw_0.vin1 li_11369_1922# 0.02024f
C266 DAC4_0.DAC3_1.DAC2_0.sw_1.vin1 DAC4_0.DAC3_0.DAC2_1.sw_0.XM6.G 0
C267 li_6_997# DAC4_0.DAC3_1.DAC2_1.sw_0.XM6.G 0
C268 avdd li_6_6443# 0.4761f
C269 DAC4_0.DAC3_1.DAC2_0.sw_1.XM8.G DAC4_0.DAC3_1.DAC2_0.sw_2.XM8.G 0
C270 DAC4_1.DAC3_1.DAC2_0.sw_0.XM6.G DAC4_1.DAC3_1.DAC2_1.vrefh 0.40159f
C271 DAC4_0.DAC3_1.DAC2_0.sw_1.XM8.G DAC4_0.DAC3_1.DAC2_0.sw_0.XM6.G 0
C272 DAC4_0.DAC3_1.DAC2_0.sw_1.XM6.G DAC4_0.DAC3_1.DAC2_0.sw_0.XM8.G 0
C273 b0 DAC4_0.DAC3_0.DAC2_0.sw_2.vin1 0
C274 DAC4_1.DAC3_1.DAC2_1.sw_0.XM8.G DAC4_1.DAC3_1.DAC2_1.sw_1.vin1 0
C275 DAC4_1.DAC3_1.vrefh b2 0.02548f
C276 b0 b2 0.33199f
C277 DAC4_1.sw_0.vin1 avdd 1.26686f
C278 DAC4_1.DAC3_0.DAC2_1.sw_1.XM6.G li_11369_4638# 0
C279 DAC4_1.DAC3_0.DAC2_0.sw_2.vin1 DAC4_1.DAC3_0.sw_0.XM6.G 0
C280 DAC4_0.DAC3_1.DAC2_1.sw_2.vin2 DAC4_0.DAC3_1.sw_0.vin2 0.22107f
C281 vrefl DAC4_1.DAC3_1.DAC2_1.sw_0.XM6.G 0.40159f
C282 DAC4_0.sw_0.vin2 b3 1.95652f
C283 DAC4_0.DAC3_1.DAC2_1.sw_2.vin1 DAC4_0.DAC3_1.DAC2_1.sw_2.vin2 0.18111f
C284 DAC4_0.DAC3_0.DAC2_0.sw_2.XM8.G DAC4_0.DAC3_0.sw_0.vin1 0.45396f
C285 DAC4_1.DAC3_0.DAC2_0.sw_2.vin2 DAC4_1.DAC3_0.DAC2_0.sw_2.XM6.G 0.40158f
C286 DAC4_0.DAC3_0.DAC2_1.sw_2.XM8.G DAC4_0.DAC3_0.sw_0.XM8.G 0
C287 DAC4_0.DAC3_0.DAC2_1.sw_1.vin2 DAC4_0.DAC3_0.DAC2_1.sw_1.XM6.G 0.40155f
C288 b1 DAC4_0.DAC3_1.DAC2_1.sw_0.XM8.G 0
C289 DAC4_1.sw_0.vin1 DAC4_1.DAC3_0.sw_0.vin1 0.25821f
C290 DAC4_0.DAC3_1.DAC2_1.sw_1.XM6.G DAC4_0.DAC3_1.DAC2_1.vrefh 0
C291 DAC4_1.DAC3_1.DAC2_0.sw_1.XM6.G DAC4_1.DAC3_1.DAC2_0.sw_0.XM8.G 0
C292 DAC4_1.DAC3_0.DAC2_0.sw_1.vin1 DAC4_1.DAC3_0.DAC2_0.sw_1.vin2 0.18076f
C293 DAC4_0.DAC3_1.DAC2_1.sw_1.vin2 DAC4_0.DAC3_1.DAC2_1.vrefh 0.00538f
C294 DAC4_0.DAC3_0.DAC2_0.sw_0.XM8.G DAC4_0.DAC3_0.DAC2_1.sw_1.vin2 0
C295 b1 DAC4_1.DAC3_1.DAC2_0.sw_0.XM6.G 0
C296 DAC4_1.DAC3_0.DAC2_1.sw_2.XM8.G DAC4_1.sw_0.vin2 0
C297 li_6_997# DAC4_0.DAC3_1.DAC2_1.sw_0.vin1 0.07492f
C298 DAC4_0.DAC3_0.DAC2_1.sw_0.XM8.G DAC4_0.DAC3_0.DAC2_1.sw_2.XM8.G 0
C299 DAC4_0.DAC3_1.DAC2_0.sw_2.XM8.G DAC4_0.DAC3_1.sw_0.vin2 0
C300 DAC4_0.DAC3_0.DAC2_1.sw_1.vin2 DAC4_0.DAC3_1.vrefh 0.01211f
C301 DAC4_1.DAC3_1.vrefh DAC4_1.DAC3_0.DAC2_1.sw_0.XM8.G 0.20379f
C302 DAC4_1.DAC3_1.DAC2_1.sw_1.XM8.G DAC4_1.DAC3_1.DAC2_1.sw_1.XM6.G 0.33977f
C303 b0 DAC4_1.DAC3_0.DAC2_1.sw_0.XM8.G 0
C304 avdd sw_0.vin2 0.85413f
C305 DAC4_1.DAC3_0.DAC2_0.sw_0.XM8.G DAC4_1.DAC3_0.DAC2_0.sw_1.XM6.G 0
C306 b1 DAC4_1.DAC3_0.DAC2_0.sw_2.XM6.G 0.12916f
C307 DAC4_1.DAC3_1.DAC2_0.sw_1.vin2 DAC4_1.DAC3_1.DAC2_0.sw_1.XM6.G 0.40155f
C308 DAC4_0.DAC3_0.sw_0.vin2 DAC4_0.DAC3_0.DAC2_0.sw_2.vin2 0
C309 li_8_9121# DAC4_0.DAC3_0.DAC2_1.sw_1.vin1 0
C310 b1 DAC4_0.DAC3_0.sw_0.vin1 0.04316f
C311 DAC4_1.DAC3_0.DAC2_1.sw_2.XM8.G DAC4_1.DAC3_0.sw_0.vin2 0.45928f
C312 DAC4_0.DAC3_0.DAC2_1.sw_2.vin2 DAC4_0.DAC3_0.sw_0.XM6.G 0
C313 li_11369_1922# DAC4_1.DAC3_0.DAC2_0.sw_0.XM6.G 0
C314 DAC4_0.DAC3_1.DAC2_1.sw_1.vin1 DAC4_0.DAC3_1.DAC2_1.vrefh 0.01177f
C315 DAC4_1.DAC3_1.DAC2_1.sw_0.XM8.G DAC4_1.DAC3_1.DAC2_1.sw_2.vin1 0
C316 DAC4_0.DAC3_1.DAC2_0.sw_1.vin1 DAC4_0.DAC3_1.DAC2_1.vrefh 0
C317 DAC4_1.DAC3_0.DAC2_1.sw_1.vin1 DAC4_1.DAC3_0.DAC2_1.sw_0.vin1 0.00795f
C318 li_6_1907# avdd 0.43969f
C319 DAC4_1.DAC3_0.DAC2_0.sw_2.vin1 DAC4_1.DAC3_0.DAC2_0.sw_2.XM6.G 0.30016f
C320 DAC4_1.DAC3_1.sw_0.XM8.G DAC4_1.DAC3_1.DAC2_1.sw_2.XM6.G 0
C321 DAC4_0.DAC3_0.DAC2_1.sw_0.XM6.G DAC4_0.DAC3_0.DAC2_1.sw_2.vin2 0.11009f
C322 DAC4_1.DAC3_1.DAC2_1.sw_1.vin1 li_11371_10942# 0
C323 DAC4_0.DAC3_1.vrefh DAC4_0.DAC3_1.DAC2_0.sw_1.vin2 0.00556f
C324 b0 li_11371_11852# 0.02486f
C325 DAC4_0.DAC3_0.DAC2_0.sw_2.XM8.G DAC4_0.sw_0.vin1 0
C326 DAC4_0.DAC3_0.DAC2_0.sw_1.XM8.G DAC4_0.DAC3_0.DAC2_0.sw_1.vin1 0.2606f
C327 DAC4_1.sw_0.vin1 DAC4_1.sw_0.vin2 0.19143f
C328 DAC4_1.DAC3_1.DAC2_0.sw_1.XM6.G DAC4_1.DAC3_1.DAC2_0.sw_2.vin2 0
C329 DAC4_1.vrefh DAC4_1.DAC3_0.DAC2_0.sw_1.XM8.G 0
C330 DAC4_0.DAC3_1.DAC2_1.sw_2.XM8.G DAC4_0.DAC3_1.DAC2_1.sw_1.XM8.G 0
C331 DAC4_0.DAC3_0.DAC2_1.sw_0.XM8.G DAC4_0.DAC3_0.DAC2_1.sw_1.XM8.G 0
C332 DAC4_1.DAC3_0.DAC2_0.sw_0.vin1 b0 0.50703f
C333 DAC4_1.DAC3_0.DAC2_1.sw_1.XM8.G DAC4_1.DAC3_0.DAC2_1.sw_2.XM6.G 0
C334 DAC4_0.DAC3_1.sw_0.XM8.G DAC4_0.DAC3_1.sw_0.vin2 0.20441f
C335 DAC4_1.DAC3_1.sw_0.XM8.G DAC4_1.DAC3_1.sw_0.vin2 0.20441f
C336 b1 DAC4_0.DAC3_0.DAC2_0.sw_1.vin1 0
C337 DAC4_0.DAC3_1.DAC2_1.sw_1.XM6.G DAC4_0.DAC3_1.DAC2_1.sw_0.XM6.G 0.00169f
C338 DAC4_0.DAC3_0.DAC2_1.sw_0.vin1 b2 0.02331f
C339 DAC4_0.DAC3_0.DAC2_1.sw_1.vin2 DAC4_0.DAC3_0.DAC2_0.sw_2.vin2 0.00781f
C340 avdd DAC4_1.vrefh 0.45963f
C341 DAC4_1.DAC3_1.vrefh DAC4_1.DAC3_0.DAC2_1.sw_2.vin2 0.20479f
C342 DAC4_0.DAC3_1.DAC2_1.sw_1.vin2 DAC4_0.DAC3_1.DAC2_1.sw_0.XM6.G 0
C343 b0 DAC4_1.DAC3_0.DAC2_1.sw_2.vin2 0
C344 DAC4_0.DAC3_1.DAC2_0.sw_2.XM6.G b2 0
C345 b2 DAC4_0.DAC3_1.DAC2_0.sw_0.XM8.G 0.00944f
C346 DAC4_1.sw_0.vin1 DAC4_1.DAC3_0.sw_0.vin2 0.32944f
C347 b1 DAC4_1.DAC3_1.DAC2_0.sw_2.XM6.G 0.12684f
C348 vrefl b1 0
C349 DAC4_0.DAC3_1.DAC2_0.sw_1.XM6.G DAC4_0.DAC3_0.DAC2_1.sw_0.XM8.G 0
C350 b1 DAC4_1.DAC3_1.DAC2_0.sw_2.XM8.G 0
C351 sw_0.vin2 vout 0.1922f
C352 DAC4_1.DAC3_1.DAC2_0.sw_2.vin1 DAC4_1.DAC3_1.DAC2_0.sw_0.XM6.G 0
C353 sw_0.vin2 DAC4_1.sw_0.vin2 0.22862f
C354 b0 DAC4_0.DAC3_0.DAC2_0.sw_1.vin2 0.28863f
C355 DAC4_1.DAC3_1.DAC2_1.sw_0.XM8.G DAC4_1.DAC3_1.DAC2_1.sw_1.XM8.G 0
C356 b1 DAC4_0.sw_0.vin1 0.0234f
C357 DAC4_0.DAC3_0.DAC2_0.sw_1.XM6.G DAC4_0.DAC3_0.DAC2_0.sw_0.XM8.G 0
C358 DAC4_0.DAC3_0.DAC2_1.sw_0.XM6.G DAC4_0.DAC3_0.DAC2_1.sw_1.vin1 0
C359 avdd DAC4_1.DAC3_1.DAC2_1.sw_2.XM8.G 0.56359f
C360 DAC4_1.DAC3_0.DAC2_1.sw_2.XM8.G DAC4_1.sw_0.vin1 0.00393f
C361 DAC4_0.DAC3_1.DAC2_1.sw_1.vin1 DAC4_0.DAC3_1.DAC2_1.sw_0.XM6.G 0
C362 DAC4_0.DAC3_1.DAC2_1.sw_1.XM6.G DAC4_0.DAC3_1.DAC2_1.sw_0.vin1 0.00197f
C363 DAC4_0.DAC3_1.DAC2_1.sw_2.XM8.G DAC4_0.DAC3_1.sw_0.vin2 0.45928f
C364 b1 DAC4_1.DAC3_1.DAC2_1.sw_0.XM6.G 0
C365 DAC4_1.DAC3_1.DAC2_0.sw_1.vin1 DAC4_1.DAC3_1.DAC2_0.sw_0.XM6.G 0
C366 DAC4_0.DAC3_1.DAC2_1.sw_2.vin1 DAC4_0.DAC3_1.DAC2_1.sw_2.XM8.G 0.26061f
C367 DAC4_0.DAC3_1.DAC2_1.sw_1.vin2 DAC4_0.DAC3_1.DAC2_1.sw_0.vin1 0.02132f
C368 DAC4_0.DAC3_1.sw_0.vin1 b2 0.18668f
C369 avdd DAC4_1.DAC3_0.DAC2_1.sw_2.vin1 0.75579f
C370 li_8_10031# avdd 0.47747f
C371 DAC4_1.DAC3_0.sw_0.vin1 DAC4_1.DAC3_0.DAC2_1.sw_2.vin1 0
C372 DAC4_1.DAC3_0.DAC2_1.sw_1.vin1 b2 0.02765f
C373 li_6_997# DAC4_0.DAC3_1.DAC2_1.sw_0.XM8.G 0
C374 DAC4_0.DAC3_1.DAC2_0.sw_2.vin2 avdd 0.73887f
C375 DAC4_0.DAC3_1.DAC2_0.sw_1.XM6.G DAC4_0.DAC3_1.DAC2_0.sw_0.XM6.G 0.00169f
C376 DAC4_1.DAC3_1.DAC2_1.sw_1.XM6.G DAC4_1.DAC3_1.DAC2_0.sw_0.XM8.G 0
C377 b0 DAC4_1.DAC3_0.DAC2_0.sw_0.XM6.G 0.12589f
C378 DAC4_1.DAC3_1.sw_0.vin1 sw_0.XM8.G 0
C379 DAC4_0.DAC3_0.DAC2_0.sw_2.XM8.G DAC4_0.DAC3_0.DAC2_0.sw_1.XM8.G 0
C380 DAC4_0.sw_0.vin1 DAC4_0.sw_0.XM6.G 0.30094f
C381 DAC4_0.DAC3_1.DAC2_1.sw_1.vin1 DAC4_0.DAC3_1.DAC2_1.sw_0.vin1 0.00795f
C382 DAC4_1.DAC3_0.DAC2_0.sw_0.XM8.G DAC4_1.DAC3_0.DAC2_1.vrefh 0.20379f
C383 DAC4_0.DAC3_0.DAC2_0.sw_0.vin1 DAC4_0.DAC3_0.DAC2_1.vrefh 0.19196f
C384 DAC4_1.DAC3_1.sw_0.vin1 DAC4_1.DAC3_1.DAC2_1.sw_2.vin1 0
C385 li_8_7301# DAC4_0.DAC3_1.vrefh 0.03589f
C386 li_8_9121# DAC4_0.DAC3_0.DAC2_1.sw_1.XM8.G 0
C387 DAC4_0.DAC3_0.DAC2_0.sw_0.vin1 DAC4_0.DAC3_0.DAC2_1.sw_1.XM8.G 0
C388 DAC4_0.DAC3_0.DAC2_1.sw_2.XM6.G DAC4_0.DAC3_0.sw_0.XM8.G 0
C389 DAC4_0.DAC3_0.DAC2_1.sw_2.XM8.G DAC4_0.DAC3_0.sw_0.XM6.G 0
C390 vrefl DAC4_1.DAC3_1.DAC2_1.sw_2.XM6.G 0
C391 b1 DAC4_0.DAC3_0.DAC2_0.sw_2.XM8.G 0
C392 DAC4_0.DAC3_0.DAC2_0.sw_1.XM6.G DAC4_0.DAC3_0.DAC2_0.sw_2.vin2 0
C393 DAC4_1.DAC3_1.DAC2_0.sw_2.vin1 DAC4_1.DAC3_1.DAC2_0.sw_2.XM6.G 0.30016f
C394 DAC4_1.DAC3_0.DAC2_0.sw_1.vin1 DAC4_1.DAC3_0.DAC2_0.sw_1.XM6.G 0.30012f
C395 DAC4_0.DAC3_1.DAC2_0.sw_1.XM8.G DAC4_0.DAC3_1.DAC2_1.vrefh 0.0014f
C396 DAC4_1.DAC3_0.DAC2_1.sw_1.vin1 DAC4_1.DAC3_0.DAC2_1.sw_0.XM8.G 0
C397 DAC4_1.DAC3_1.DAC2_0.sw_2.XM8.G DAC4_1.DAC3_1.DAC2_0.sw_2.vin1 0.26061f
C398 DAC4_1.DAC3_0.DAC2_1.sw_1.XM8.G DAC4_1.DAC3_0.DAC2_1.sw_0.vin1 0
C399 DAC4_0.DAC3_0.DAC2_0.sw_0.XM6.G DAC4_0.DAC3_0.DAC2_1.sw_1.vin2 0
C400 b1 DAC4_1.DAC3_0.DAC2_0.sw_2.vin2 0.37498f
C401 b1 DAC4_1.DAC3_1.DAC2_1.vrefh 0
C402 DAC4_0.DAC3_0.DAC2_1.sw_0.XM8.G DAC4_0.DAC3_0.DAC2_1.sw_2.XM6.G 0
C403 avdd li_11371_9136# 0.47589f
C404 DAC4_1.sw_0.vin2 DAC4_1.DAC3_1.DAC2_1.sw_2.XM8.G 0
C405 DAC4_1.DAC3_1.DAC2_0.sw_2.XM6.G b3 0
C406 DAC4_0.DAC3_0.sw_0.XM8.G b2 0
C407 DAC4_1.DAC3_1.DAC2_0.sw_2.XM8.G b3 0
C408 DAC4_1.DAC3_1.DAC2_0.sw_2.XM6.G DAC4_1.DAC3_1.sw_0.vin2 0
C409 DAC4_1.DAC3_1.DAC2_1.sw_0.vin1 DAC4_1.DAC3_1.DAC2_1.sw_1.vin1 0.00795f
C410 DAC4_1.DAC3_1.DAC2_0.sw_2.XM8.G DAC4_1.DAC3_1.sw_0.vin2 0
C411 DAC4_1.DAC3_1.DAC2_0.sw_1.XM6.G b2 0.00217f
C412 li_11369_4638# DAC4_1.DAC3_0.DAC2_1.sw_2.vin1 0
C413 DAC4_1.sw_0.vin1 sw_0.vin2 0.29382f
C414 DAC4_0.DAC3_0.DAC2_1.sw_0.XM8.G b2 0.00948f
C415 b1 DAC4_0.DAC3_0.DAC2_0.sw_1.XM8.G 0
C416 DAC4_0.sw_0.vin1 b3 0.25408f
C417 DAC4_1.DAC3_1.DAC2_1.sw_0.vin1 DAC4_1.DAC3_1.DAC2_1.sw_1.vin2 0.02132f
C418 DAC4_1.DAC3_0.DAC2_0.sw_2.vin2 DAC4_1.DAC3_0.DAC2_0.sw_2.vin1 0.18091f
C419 sw_0.vin1 avdd 1.12431f
C420 DAC4_0.DAC3_1.DAC2_0.sw_2.vin2 DAC4_0.DAC3_1.DAC2_0.sw_0.vin1 0.27819f
C421 DAC4_1.DAC3_0.DAC2_1.sw_0.XM6.G li_11369_5548# 0
C422 b0 DAC4_0.DAC3_0.DAC2_1.sw_2.vin1 0
C423 DAC4_1.DAC3_1.DAC2_1.sw_1.XM6.G DAC4_1.DAC3_1.DAC2_0.sw_2.vin2 0
C424 DAC4_1.DAC3_0.DAC2_1.sw_2.vin1 DAC4_1.DAC3_0.sw_0.vin2 0.2842f
C425 DAC4_0.DAC3_1.DAC2_1.sw_2.vin2 b2 0.37943f
C426 DAC4_1.DAC3_0.DAC2_1.sw_1.XM6.G DAC4_1.DAC3_0.DAC2_1.sw_2.vin1 0.11006f
C427 b0 li_6_4623# 0.01482f
C428 DAC4_1.DAC3_1.DAC2_0.sw_1.XM6.G DAC4_1.DAC3_0.DAC2_1.sw_0.XM8.G 0
C429 DAC4_0.DAC3_1.DAC2_1.sw_2.XM6.G DAC4_0.DAC3_1.DAC2_1.sw_1.XM8.G 0
C430 DAC4_0.DAC3_0.DAC2_1.sw_0.XM6.G DAC4_0.DAC3_0.DAC2_1.sw_1.XM8.G 0
C431 avdd DAC4_0.DAC3_0.DAC2_1.sw_1.XM6.G 1.05416f
C432 b1 DAC4_1.DAC3_0.DAC2_0.sw_2.vin1 0.41171f
C433 li_11371_10046# DAC4_1.DAC3_1.DAC2_1.vrefh 0.03589f
C434 DAC4_0.DAC3_1.DAC2_1.sw_1.XM6.G DAC4_0.DAC3_1.DAC2_1.sw_0.XM8.G 0
C435 DAC4_0.DAC3_1.sw_0.XM6.G DAC4_0.DAC3_1.sw_0.vin2 0.40444f
C436 DAC4_0.DAC3_1.DAC2_1.sw_1.XM8.G DAC4_0.DAC3_1.DAC2_1.sw_0.XM6.G 0
C437 DAC4_0.DAC3_1.DAC2_1.sw_2.vin1 DAC4_0.DAC3_1.sw_0.XM6.G 0
C438 DAC4_0.DAC3_1.DAC2_0.sw_2.XM8.G b2 0
C439 DAC4_1.DAC3_0.DAC2_1.sw_2.XM8.G DAC4_1.DAC3_0.DAC2_1.sw_2.vin1 0.26061f
C440 b0 DAC4_0.DAC3_1.DAC2_0.sw_2.vin1 0
C441 b2 DAC4_0.DAC3_1.DAC2_0.sw_0.XM6.G 0.00214f
C442 avdd DAC4_0.DAC3_1.vrefh 0.62096f
C443 DAC4_0.DAC3_0.DAC2_0.sw_0.XM8.G avdd 0.56264f
C444 DAC4_1.DAC3_1.DAC2_1.sw_1.vin1 DAC4_1.DAC3_1.DAC2_0.sw_0.XM6.G 0
C445 DAC4_0.DAC3_1.DAC2_0.sw_1.XM6.G DAC4_0.DAC3_0.DAC2_1.sw_0.XM6.G 0
C446 b1 DAC4_0.sw_0.XM6.G 0
C447 li_11369_3728# avdd 0.47747f
C448 DAC4_1.DAC3_1.DAC2_0.sw_2.vin1 DAC4_1.DAC3_1.DAC2_1.vrefh 0.01454f
C449 DAC4_1.DAC3_0.DAC2_1.sw_1.XM8.G b2 0.01159f
C450 DAC4_1.DAC3_0.DAC2_0.sw_0.XM8.G DAC4_1.DAC3_0.DAC2_0.sw_2.XM6.G 0
C451 li_11369_2832# DAC4_1.DAC3_0.DAC2_1.vrefh 0.03589f
C452 b0 li_8_8211# 0.0158f
C453 sw_0.vin1 vout 0.2578f
C454 DAC4_1.DAC3_1.DAC2_0.sw_0.XM6.G DAC4_1.DAC3_1.DAC2_1.sw_1.vin2 0
C455 DAC4_0.DAC3_0.DAC2_0.sw_1.XM6.G DAC4_0.DAC3_0.DAC2_0.sw_0.XM6.G 0.00169f
C456 sw_0.vin1 DAC4_1.sw_0.vin2 0.00162f
C457 DAC4_0.DAC3_1.DAC2_1.sw_2.XM6.G DAC4_0.DAC3_1.sw_0.vin2 0.11125f
C458 DAC4_1.DAC3_1.DAC2_0.sw_1.vin1 DAC4_1.DAC3_1.DAC2_1.vrefh 0
C459 DAC4_0.DAC3_1.DAC2_1.sw_1.vin1 DAC4_0.DAC3_1.DAC2_1.sw_0.XM8.G 0
C460 DAC4_0.DAC3_1.DAC2_1.sw_1.XM8.G DAC4_0.DAC3_1.DAC2_1.sw_0.vin1 0
C461 DAC4_0.DAC3_1.DAC2_1.sw_2.vin1 DAC4_0.DAC3_1.DAC2_1.sw_2.XM6.G 0.30016f
C462 DAC4_0.DAC3_1.DAC2_1.sw_2.vin1 DAC4_0.DAC3_1.DAC2_1.sw_0.XM6.G 0
C463 b1 DAC4_1.DAC3_1.DAC2_1.sw_2.XM6.G 0.12504f
C464 DAC4_1.DAC3_1.DAC2_0.sw_1.XM6.G DAC4_1.DAC3_0.DAC2_1.sw_2.vin2 0
C465 b1 DAC4_1.DAC3_1.DAC2_0.sw_2.vin1 0.38049f
C466 DAC4_1.sw_0.vin1 DAC4_1.DAC3_0.DAC2_1.sw_2.vin1 0.00307f
C467 avdd DAC4_1.sw_0.XM8.G 0.56187f
C468 DAC4_1.DAC3_0.DAC2_1.sw_1.vin1 DAC4_1.DAC3_0.DAC2_0.sw_0.XM6.G 0
C469 DAC4_1.DAC3_0.DAC2_1.sw_1.vin2 DAC4_1.DAC3_0.DAC2_1.vrefh 0.00538f
C470 DAC4_1.DAC3_0.DAC2_1.sw_1.XM8.G DAC4_1.DAC3_0.DAC2_1.sw_0.XM8.G 0
C471 DAC4_1.DAC3_0.DAC2_0.sw_1.vin1 DAC4_1.DAC3_0.DAC2_1.vrefh 0
C472 DAC4_0.DAC3_1.sw_0.XM8.G b2 0
C473 DAC4_1.DAC3_0.DAC2_0.sw_1.vin2 b2 0.02251f
C474 b1 b3 0.18834f
C475 DAC4_0.DAC3_1.DAC2_0.sw_1.XM8.G DAC4_0.sw_0.vin2 0
C476 b1 DAC4_1.DAC3_1.sw_0.vin2 0.05719f
C477 DAC4_1.DAC3_1.DAC2_1.sw_0.vin1 DAC4_1.DAC3_1.DAC2_1.sw_1.XM8.G 0
C478 avdd DAC4_0.DAC3_0.DAC2_0.sw_2.vin2 0.73887f
C479 DAC4_1.DAC3_1.DAC2_0.sw_1.XM8.G li_11371_8226# 0
C480 b1 DAC4_1.DAC3_1.DAC2_0.sw_1.vin1 0.0015f
C481 li_11369_102# DAC4_1.DAC3_0.DAC2_0.sw_1.vin1 0
C482 DAC4_1.DAC3_1.sw_0.vin1 DAC4_1.DAC3_1.sw_0.XM6.G 0.30206f
C483 b0 DAC4_0.DAC3_0.DAC2_1.sw_1.vin2 0.2977f
C484 li_6_4623# DAC4_0.DAC3_1.DAC2_0.sw_0.XM8.G 0
C485 DAC4_0.DAC3_0.DAC2_1.sw_2.XM6.G DAC4_0.DAC3_0.sw_0.XM6.G 0
C486 vrefl DAC4_1.DAC3_1.DAC2_1.sw_1.vin1 0
C487 DAC4_0.DAC3_1.DAC2_0.sw_1.XM6.G DAC4_0.DAC3_1.DAC2_1.vrefh 0.00122f
C488 DAC4_0.DAC3_0.DAC2_0.sw_2.vin1 DAC4_0.DAC3_0.sw_0.XM6.G 0
C489 DAC4_0.DAC3_1.DAC2_0.sw_2.XM6.G DAC4_0.DAC3_1.DAC2_0.sw_2.vin1 0.30016f
C490 vrefl DAC4_1.DAC3_1.DAC2_1.sw_1.vin2 0.01211f
C491 DAC4_0.DAC3_1.DAC2_1.sw_2.XM8.G b2 0
C492 DAC4_0.DAC3_1.DAC2_0.sw_2.vin1 DAC4_0.DAC3_1.DAC2_0.sw_0.XM8.G 0
C493 DAC4_1.DAC3_1.sw_0.vin1 DAC4_1.DAC3_1.DAC2_0.sw_0.XM8.G 0
C494 DAC4_0.DAC3_1.sw_0.vin2 DAC4_0.sw_0.vin2 0.20264f
C495 DAC4_0.DAC3_0.sw_0.XM6.G b2 0.12249f
C496 DAC4_1.DAC3_0.DAC2_0.sw_0.vin1 DAC4_1.DAC3_0.DAC2_1.sw_1.XM8.G 0
C497 DAC4_0.sw_0.XM6.G b3 0.12902f
C498 li_8_8211# DAC4_0.DAC3_0.DAC2_1.sw_0.vin1 0.0203f
C499 DAC4_0.DAC3_0.DAC2_0.sw_0.XM8.G li_8_11837# 0
C500 DAC4_1.DAC3_0.DAC2_1.sw_1.XM8.G DAC4_1.DAC3_0.DAC2_1.sw_2.vin2 0
C501 DAC4_1.DAC3_1.DAC2_1.sw_1.vin1 DAC4_1.DAC3_1.DAC2_1.sw_0.XM6.G 0
C502 DAC4_0.DAC3_0.DAC2_1.sw_0.XM6.G b2 0.00215f
C503 b0 DAC4_0.DAC3_1.DAC2_0.sw_1.vin2 0.29748f
C504 DAC4_1.DAC3_1.DAC2_1.sw_0.XM6.G DAC4_1.DAC3_1.DAC2_1.sw_1.vin2 0
C505 DAC4_1.sw_0.vin2 DAC4_1.sw_0.XM8.G 0.20434f
C506 DAC4_1.sw_0.vin1 sw_0.vin1 0
C507 DAC4_1.DAC3_1.DAC2_0.sw_0.vin1 DAC4_1.DAC3_1.DAC2_0.sw_0.XM6.G 0.30012f
C508 DAC4_0.DAC3_1.sw_0.vin1 DAC4_0.DAC3_1.DAC2_0.sw_2.vin1 0.26064f
C509 sw_0.XM8.G DAC4_1.DAC3_1.DAC2_0.sw_2.XM8.G 0
C510 avdd li_11371_8226# 0.44133f
C511 DAC4_1.DAC3_1.DAC2_1.sw_2.XM6.G DAC4_1.DAC3_1.sw_0.vin2 0.11125f
C512 DAC4_1.DAC3_1.DAC2_0.sw_2.vin1 b3 0.00714f
C513 DAC4_1.DAC3_1.DAC2_0.sw_2.vin1 DAC4_1.DAC3_1.sw_0.vin2 0
C514 vrefl DAC4_1.DAC3_1.DAC2_1.sw_2.vin1 0.01454f
C515 DAC4_0.DAC3_0.DAC2_1.sw_2.XM8.G DAC4_0.sw_0.vin2 0
C516 DAC4_1.DAC3_0.DAC2_0.sw_0.vin1 DAC4_1.DAC3_0.DAC2_0.sw_1.vin2 0.02132f
C517 b0 li_11369_1012# 0.02486f
C518 DAC4_0.sw_0.vin1 sw_0.XM8.G 0
C519 DAC4_1.DAC3_1.DAC2_0.sw_1.vin1 DAC4_1.DAC3_1.DAC2_0.sw_2.vin1 0.25815f
C520 DAC4_0.DAC3_1.DAC2_1.sw_1.XM8.G DAC4_0.DAC3_1.DAC2_1.sw_0.XM8.G 0
C521 DAC4_1.DAC3_1.DAC2_1.sw_2.vin2 avdd 0.72339f
C522 DAC4_1.DAC3_1.sw_0.vin1 DAC4_1.DAC3_1.DAC2_0.sw_2.vin2 0.21091f
C523 DAC4_0.DAC3_0.DAC2_0.sw_0.vin1 DAC4_0.DAC3_0.DAC2_0.sw_1.vin2 0.02132f
C524 DAC4_1.DAC3_1.DAC2_1.sw_1.XM6.G li_11371_11852# 0
C525 DAC4_1.DAC3_0.DAC2_0.sw_0.XM8.G DAC4_1.DAC3_0.DAC2_0.sw_2.vin2 0.46313f
C526 DAC4_0.DAC3_0.DAC2_1.sw_1.vin2 DAC4_0.DAC3_0.DAC2_1.sw_0.vin1 0.02132f
C527 DAC4_0.DAC3_0.sw_0.vin1 DAC4_0.DAC3_0.DAC2_1.sw_2.vin2 0
C528 sw_0.vin1 sw_0.vin2 0.19674f
C529 DAC4_0.DAC3_0.DAC2_1.sw_2.vin1 DAC4_0.DAC3_0.DAC2_1.sw_0.XM8.G 0
C530 DAC4_1.DAC3_0.DAC2_1.sw_2.XM8.G DAC4_1.sw_0.XM8.G 0
C531 li_8_11837# DAC4_0.DAC3_0.DAC2_0.sw_2.vin2 0
C532 b0 DAC4_1.DAC3_0.DAC2_0.sw_2.XM8.G 0
C533 DAC4_1.DAC3_1.DAC2_1.sw_0.XM6.G DAC4_1.DAC3_1.DAC2_1.sw_2.vin1 0
C534 DAC4_0.DAC3_0.DAC2_0.sw_0.XM6.G avdd 1.05218f
C535 DAC4_1.sw_0.XM6.G DAC4_1.DAC3_1.sw_0.vin1 0
C536 DAC4_1.DAC3_1.DAC2_1.sw_1.vin1 DAC4_1.DAC3_1.DAC2_1.vrefh 0.01177f
C537 b0 DAC4_0.DAC3_0.DAC2_0.sw_1.XM6.G 0.12531f
C538 DAC4_0.DAC3_1.DAC2_0.sw_2.XM8.G DAC4_0.sw_0.XM8.G 0
C539 b0 li_6_2817# 0.01593f
C540 DAC4_1.DAC3_1.DAC2_1.vrefh DAC4_1.DAC3_1.DAC2_1.sw_1.vin2 0.00538f
C541 b1 DAC4_1.DAC3_0.DAC2_1.sw_0.XM6.G 0
C542 b1 DAC4_1.DAC3_0.DAC2_0.sw_0.XM8.G 0.00175f
C543 DAC4_0.DAC3_1.DAC2_1.vrefh b2 0.02529f
C544 DAC4_1.DAC3_1.sw_0.XM8.G DAC4_1.DAC3_1.sw_0.XM6.G 0.33977f
C545 b1 DAC4_0.DAC3_1.DAC2_1.sw_1.XM6.G 0
C546 DAC4_1.DAC3_0.sw_0.XM6.G DAC4_1.DAC3_0.DAC2_1.sw_2.XM6.G 0
C547 DAC4_0.DAC3_1.DAC2_1.sw_2.vin1 DAC4_0.DAC3_1.DAC2_1.sw_0.XM8.G 0
C548 b1 DAC4_1.DAC3_1.DAC2_1.sw_1.vin1 0.01414f
C549 DAC4_0.DAC3_0.DAC2_1.sw_0.vin1 DAC4_0.DAC3_1.DAC2_0.sw_1.vin2 0
C550 vrefl DAC4_1.DAC3_1.DAC2_1.sw_1.XM8.G 0.0014f
C551 DAC4_0.DAC3_1.DAC2_1.sw_1.vin2 b1 0
C552 DAC4_0.DAC3_0.DAC2_1.sw_0.XM8.G DAC4_0.DAC3_1.DAC2_0.sw_2.vin1 0
C553 li_11369_1922# avdd 0.47589f
C554 DAC4_1.sw_0.vin1 DAC4_1.sw_0.XM8.G 0.261f
C555 DAC4_1.DAC3_0.DAC2_0.sw_0.XM8.G DAC4_1.DAC3_0.DAC2_0.sw_2.vin1 0
C556 DAC4_1.DAC3_0.DAC2_0.sw_1.vin2 DAC4_1.DAC3_0.DAC2_0.sw_0.XM6.G 0
C557 b0 li_8_12747# 0.0239f
C558 b1 DAC4_1.DAC3_1.DAC2_1.sw_1.vin2 0.01557f
C559 DAC4_0.DAC3_1.sw_0.XM6.G b2 0.12249f
C560 b0 li_8_7301# 0.01256f
C561 DAC4_1.DAC3_0.DAC2_0.sw_1.XM6.G b2 0.002f
C562 li_8_8211# DAC4_0.DAC3_0.DAC2_1.sw_0.XM8.G 0
C563 DAC4_1.DAC3_1.DAC2_1.sw_2.vin2 DAC4_1.sw_0.vin2 0.00324f
C564 DAC4_0.sw_0.vin1 DAC4_0.DAC3_0.DAC2_1.sw_2.vin2 0.02056f
C565 DAC4_1.DAC3_1.DAC2_1.sw_1.XM8.G DAC4_1.DAC3_1.DAC2_1.sw_0.XM6.G 0
C566 DAC4_0.DAC3_0.sw_0.vin2 DAC4_0.DAC3_0.sw_0.XM8.G 0.20441f
C567 b1 DAC4_0.DAC3_1.DAC2_1.sw_1.vin1 0.00152f
C568 li_6_4623# DAC4_0.DAC3_1.DAC2_0.sw_0.XM6.G 0
C569 b0 DAC4_1.DAC3_1.DAC2_0.sw_1.XM8.G 0
C570 b1 DAC4_0.DAC3_1.DAC2_0.sw_1.vin1 0.0015f
C571 sw_0.vin2 DAC4_1.sw_0.XM8.G 0.46507f
C572 DAC4_1.DAC3_1.DAC2_0.sw_0.XM8.G DAC4_1.DAC3_1.DAC2_0.sw_0.XM6.G 0.33977f
C573 DAC4_0.DAC3_1.DAC2_0.sw_2.XM8.G DAC4_0.DAC3_1.DAC2_0.sw_2.vin1 0.26061f
C574 DAC4_0.DAC3_0.DAC2_1.sw_2.vin1 li_8_9121# 0
C575 DAC4_0.DAC3_1.DAC2_0.sw_2.vin1 DAC4_0.DAC3_1.DAC2_0.sw_0.XM6.G 0
C576 DAC4_0.DAC3_1.DAC2_1.sw_2.XM6.G b2 0.00111f
C577 DAC4_0.DAC3_1.DAC2_1.sw_0.XM6.G b2 0.00137f
C578 b1 DAC4_1.DAC3_1.DAC2_1.sw_2.vin1 0.4012f
C579 DAC4_0.DAC3_0.DAC2_0.sw_0.XM6.G li_8_11837# 0
C580 DAC4_1.DAC3_1.DAC2_0.sw_1.vin2 DAC4_1.DAC3_1.DAC2_0.sw_0.XM6.G 0
C581 DAC4_1.DAC3_1.sw_0.vin1 b2 0.18668f
C582 DAC4_1.DAC3_0.DAC2_1.sw_0.XM6.G DAC4_1.DAC3_1.DAC2_0.sw_1.vin1 0
C583 DAC4_0.DAC3_0.sw_0.vin1 DAC4_0.DAC3_0.DAC2_1.sw_2.XM8.G 0
C584 DAC4_1.DAC3_1.DAC2_0.sw_0.vin1 DAC4_1.DAC3_1.DAC2_1.vrefh 0.19196f
C585 DAC4_1.DAC3_1.DAC2_1.sw_1.vin1 DAC4_1.DAC3_1.sw_0.vin2 0
C586 DAC4_1.DAC3_0.DAC2_0.sw_2.vin2 DAC4_1.DAC3_0.DAC2_1.sw_1.vin2 0.00781f
C587 DAC4_0.DAC3_1.DAC2_1.sw_0.vin1 b2 0.02283f
C588 b0 DAC4_1.DAC3_0.DAC2_0.sw_1.XM8.G 0
C589 DAC4_1.DAC3_0.DAC2_0.sw_0.vin1 DAC4_1.DAC3_0.DAC2_0.sw_1.XM6.G 0.00197f
C590 DAC4_1.DAC3_1.DAC2_0.sw_2.XM6.G DAC4_1.DAC3_1.sw_0.XM6.G 0
C591 DAC4_0.DAC3_0.DAC2_1.sw_2.vin1 DAC4_0.DAC3_0.sw_0.XM6.G 0
C592 DAC4_1.DAC3_1.vrefh avdd 0.62096f
C593 DAC4_1.DAC3_1.DAC2_0.sw_2.XM8.G DAC4_1.DAC3_1.sw_0.XM6.G 0
C594 DAC4_1.DAC3_1.DAC2_0.sw_2.vin2 DAC4_1.DAC3_1.DAC2_0.sw_0.XM6.G 0.11009f
C595 b0 avdd 18.353f
C596 DAC4_1.DAC3_0.DAC2_1.sw_0.vin1 li_11369_5548# 0.0203f
C597 DAC4_0.sw_0.vin2 b2 0
C598 DAC4_1.DAC3_1.DAC2_0.sw_2.XM6.G DAC4_1.DAC3_1.DAC2_0.sw_0.XM8.G 0
C599 b1 DAC4_1.DAC3_1.DAC2_1.sw_1.XM8.G 0.00578f
C600 b1 DAC4_1.DAC3_1.DAC2_0.sw_0.vin1 0
C601 DAC4_0.DAC3_0.DAC2_1.sw_2.vin1 DAC4_0.DAC3_0.DAC2_1.sw_0.XM6.G 0
C602 DAC4_1.DAC3_1.DAC2_0.sw_2.XM8.G DAC4_1.DAC3_1.DAC2_0.sw_0.XM8.G 0
C603 DAC4_0.DAC3_0.DAC2_1.sw_0.XM8.G DAC4_0.DAC3_1.DAC2_0.sw_1.vin2 0
C604 b1 DAC4_0.DAC3_0.DAC2_1.sw_2.vin2 0.32584f
C605 DAC4_1.DAC3_1.DAC2_1.sw_2.XM6.G DAC4_1.DAC3_1.DAC2_1.sw_2.vin1 0.30016f
C606 b1 DAC4_1.DAC3_0.DAC2_1.sw_1.vin2 0
C607 DAC4_0.DAC3_1.DAC2_0.sw_1.vin1 b3 0
C608 b1 DAC4_1.DAC3_0.DAC2_0.sw_1.vin1 0.00159f
C609 b2 DAC4_1.DAC3_0.DAC2_1.vrefh 0.02548f
C610 DAC4_0.sw_0.vin1 DAC4_0.DAC3_0.DAC2_1.sw_2.XM8.G 0.00454f
C611 DAC4_0.DAC3_0.DAC2_0.sw_1.vin2 li_8_13657# 0
C612 DAC4_1.DAC3_1.DAC2_1.sw_2.vin1 DAC4_1.DAC3_1.sw_0.vin2 0.2842f
C613 b1 DAC4_0.DAC3_1.DAC2_1.sw_1.XM8.G 0.00287f
C614 DAC4_1.DAC3_0.DAC2_0.sw_2.vin1 DAC4_1.DAC3_0.DAC2_0.sw_1.vin1 0.25815f
C615 b1 DAC4_0.DAC3_1.DAC2_0.sw_1.XM8.G 0.00186f
C616 DAC4_0.DAC3_0.DAC2_1.vrefh DAC4_0.DAC3_0.DAC2_0.sw_1.vin1 0
C617 b0 DAC4_0.DAC3_1.DAC2_0.sw_0.vin1 0.50703f
C618 DAC4_0.DAC3_0.DAC2_0.sw_2.vin1 DAC4_0.DAC3_0.DAC2_0.sw_2.XM6.G 0.3002f
C619 DAC4_0.DAC3_0.DAC2_0.sw_0.vin1 DAC4_0.DAC3_0.DAC2_1.sw_1.vin2 0
C620 DAC4_0.DAC3_0.DAC2_1.sw_1.vin2 li_8_9121# 0.02113f
C621 DAC4_0.sw_0.XM6.G DAC4_0.DAC3_0.DAC2_1.sw_2.vin2 0
C622 DAC4_0.DAC3_0.DAC2_0.sw_2.XM6.G b2 0
C623 DAC4_1.DAC3_0.DAC2_0.sw_1.XM6.G DAC4_1.DAC3_0.DAC2_0.sw_0.XM6.G 0.00169f
C624 DAC4_0.DAC3_1.DAC2_0.sw_1.vin2 DAC4_0.DAC3_1.DAC2_0.sw_0.XM6.G 0
C625 b0 li_11369_4638# 0.02486f
C626 b1 DAC4_0.DAC3_0.DAC2_1.sw_1.vin1 0.00152f
C627 DAC4_1.DAC3_1.DAC2_0.sw_2.XM6.G DAC4_1.DAC3_1.DAC2_0.sw_2.vin2 0.40158f
C628 DAC4_1.DAC3_1.DAC2_0.sw_2.XM8.G DAC4_1.DAC3_1.DAC2_0.sw_2.vin2 0.20378f
C629 li_8_8211# DAC4_0.DAC3_0.DAC2_1.sw_0.XM6.G 0
C630 DAC4_1.DAC3_0.sw_0.XM6.G b2 0.12249f
C631 DAC4_0.DAC3_0.sw_0.vin2 DAC4_0.DAC3_0.sw_0.XM6.G 0.40444f
C632 DAC4_0.DAC3_0.DAC2_1.sw_0.vin1 avdd 0.72828f
C633 DAC4_1.sw_0.XM6.G DAC4_1.DAC3_1.DAC2_0.sw_2.XM6.G 0
C634 DAC4_1.DAC3_1.DAC2_1.sw_1.XM8.G DAC4_1.DAC3_1.DAC2_1.sw_2.XM6.G 0
C635 DAC4_1.sw_0.XM6.G DAC4_1.DAC3_1.DAC2_0.sw_2.XM8.G 0
C636 DAC4_1.DAC3_1.sw_0.XM8.G b2 0
C637 b1 DAC4_0.DAC3_1.sw_0.vin2 0.10362f
C638 DAC4_0.DAC3_1.DAC2_1.sw_2.vin1 b1 0.3838f
C639 li_11371_12762# avdd 0.19011f
C640 DAC4_0.DAC3_1.DAC2_0.sw_2.XM6.G avdd 1.05309f
C641 DAC4_1.DAC3_0.DAC2_1.sw_1.XM6.G DAC4_1.DAC3_1.vrefh 0.00122f
C642 DAC4_1.DAC3_1.DAC2_0.sw_0.XM8.G DAC4_1.DAC3_1.DAC2_1.vrefh 0.20379f
C643 avdd DAC4_0.DAC3_1.DAC2_0.sw_0.XM8.G 0.56264f
C644 b0 DAC4_1.DAC3_0.DAC2_1.sw_1.XM6.G 0.12643f
C645 DAC4_0.DAC3_0.DAC2_0.sw_0.XM8.G DAC4_0.DAC3_0.DAC2_1.sw_1.XM6.G 0
C646 b0 li_8_11837# 0.01482f
C647 DAC4_0.DAC3_1.vrefh DAC4_0.DAC3_0.DAC2_1.sw_1.XM6.G 0.00122f
C648 DAC4_1.DAC3_1.DAC2_1.sw_1.XM8.G DAC4_1.DAC3_1.sw_0.vin2 0
C649 DAC4_0.DAC3_0.DAC2_1.sw_2.vin2 b3 0.0039f
C650 DAC4_0.DAC3_1.DAC2_1.sw_0.XM8.G b2 0.0077f
C651 DAC4_1.DAC3_1.DAC2_0.sw_1.vin1 DAC4_1.DAC3_1.DAC2_0.sw_0.vin1 0.00795f
C652 sw_0.vin1 DAC4_1.sw_0.XM8.G 0
C653 b1 DAC4_1.DAC3_1.sw_0.XM6.G 0
C654 DAC4_1.DAC3_0.DAC2_0.sw_0.vin1 DAC4_1.DAC3_0.DAC2_1.vrefh 0.19196f
C655 DAC4_0.DAC3_1.DAC2_1.vrefh li_6_4623# 0
C656 DAC4_1.DAC3_1.DAC2_0.sw_0.XM6.G b2 0.00214f
C657 DAC4_1.DAC3_1.DAC2_1.sw_2.vin2 DAC4_1.DAC3_1.DAC2_1.sw_2.XM8.G 0.20378f
C658 DAC4_1.DAC3_1.DAC2_0.sw_1.vin2 DAC4_1.DAC3_1.DAC2_1.vrefh 0.01211f
C659 DAC4_0.DAC3_1.DAC2_1.sw_1.vin2 DAC4_0.DAC3_1.DAC2_1.sw_1.XM6.G 0.40155f
C660 DAC4_1.DAC3_0.DAC2_1.sw_0.XM8.G li_11369_5548# 0
C661 DAC4_0.DAC3_0.sw_0.vin1 DAC4_0.DAC3_0.DAC2_1.sw_2.XM6.G 0
C662 b1 DAC4_1.DAC3_0.DAC2_1.sw_2.XM6.G 0.12673f
C663 DAC4_0.DAC3_0.DAC2_1.sw_1.vin2 DAC4_0.DAC3_0.DAC2_1.sw_0.XM6.G 0
C664 DAC4_0.DAC3_1.sw_0.vin1 avdd 1.69019f
C665 DAC4_0.DAC3_1.DAC2_1.vrefh DAC4_0.DAC3_1.DAC2_0.sw_2.vin1 0.01454f
C666 b1 DAC4_1.DAC3_1.DAC2_0.sw_0.XM8.G 0.00176f
C667 b1 DAC4_0.DAC3_0.DAC2_1.sw_2.XM8.G 0
C668 DAC4_1.DAC3_1.DAC2_0.sw_1.XM8.G DAC4_1.DAC3_1.DAC2_0.sw_1.XM6.G 0.33977f
C669 DAC4_1.DAC3_0.DAC2_0.sw_2.XM6.G b2 0
C670 DAC4_1.DAC3_1.DAC2_1.sw_1.vin1 DAC4_1.DAC3_1.DAC2_1.sw_1.vin2 0.18076f
C671 li_11369_1012# DAC4_1.DAC3_0.DAC2_0.sw_1.vin2 0.02113f
C672 DAC4_0.DAC3_0.sw_0.vin1 DAC4_0.DAC3_0.DAC2_0.sw_2.vin1 0.26064f
C673 DAC4_0.DAC3_1.DAC2_0.sw_1.XM8.G b3 0
C674 DAC4_1.DAC3_0.DAC2_1.sw_1.vin1 avdd 0.67222f
C675 DAC4_0.DAC3_0.sw_0.vin1 b2 0.18607f
C676 DAC4_0.DAC3_1.DAC2_0.sw_0.vin1 DAC4_0.DAC3_1.DAC2_0.sw_0.XM8.G 0.2606f
C677 b0 li_6_6443# 0.01691f
C678 DAC4_0.DAC3_0.DAC2_0.sw_0.vin1 DAC4_0.DAC3_0.DAC2_0.sw_1.XM6.G 0.00197f
C679 b1 DAC4_1.DAC3_1.DAC2_0.sw_1.vin2 0
C680 DAC4_1.DAC3_1.DAC2_0.sw_2.vin2 DAC4_1.DAC3_1.DAC2_1.vrefh 0.2049f
C681 DAC4_0.DAC3_1.DAC2_1.sw_1.XM6.G DAC4_0.DAC3_1.DAC2_1.sw_1.vin1 0.30012f
C682 DAC4_0.DAC3_1.sw_0.XM6.G DAC4_0.DAC3_1.DAC2_0.sw_2.vin1 0
C683 DAC4_0.DAC3_0.DAC2_1.sw_1.XM6.G DAC4_0.DAC3_0.DAC2_0.sw_2.vin2 0
C684 DAC4_0.DAC3_1.DAC2_1.sw_1.vin2 DAC4_0.DAC3_1.DAC2_1.sw_1.vin1 0.18076f
C685 DAC4_1.DAC3_0.sw_0.XM6.G DAC4_1.DAC3_0.DAC2_1.sw_2.vin2 0
C686 DAC4_0.DAC3_0.DAC2_1.vrefh DAC4_0.DAC3_0.DAC2_0.sw_1.XM8.G 0.0014f
C687 DAC4_0.DAC3_0.DAC2_1.sw_0.XM6.G DAC4_0.DAC3_1.DAC2_0.sw_1.vin2 0
C688 DAC4_0.DAC3_0.DAC2_0.sw_2.vin1 DAC4_0.DAC3_0.DAC2_0.sw_1.vin1 0.25815f
C689 DAC4_0.DAC3_0.DAC2_0.sw_0.XM8.G DAC4_0.DAC3_0.DAC2_0.sw_2.vin2 0.46314f
C690 DAC4_0.sw_0.XM6.G DAC4_0.DAC3_0.DAC2_1.sw_2.XM8.G 0
C691 DAC4_1.DAC3_1.DAC2_1.sw_1.vin1 DAC4_1.DAC3_1.DAC2_1.sw_2.vin1 0.25815f
C692 DAC4_1.DAC3_0.DAC2_0.sw_0.XM6.G DAC4_1.DAC3_0.DAC2_1.vrefh 0.40159f
C693 DAC4_1.DAC3_0.DAC2_1.sw_2.vin2 li_11369_5548# 0
C694 b1 DAC4_0.DAC3_0.DAC2_1.vrefh 0.01487f
C695 DAC4_1.DAC3_1.DAC2_1.sw_2.XM6.G DAC4_1.DAC3_1.sw_0.XM6.G 0
C696 b1 DAC4_0.DAC3_0.DAC2_1.sw_1.XM8.G 0.00287f
C697 avdd DAC4_0.DAC3_0.sw_0.XM8.G 0.56426f
C698 DAC4_0.sw_0.XM8.G DAC4_0.sw_0.vin2 0.20425f
C699 b1 DAC4_1.DAC3_1.DAC2_0.sw_2.vin2 0.32859f
C700 DAC4_0.sw_0.vin1 DAC4_0.DAC3_0.DAC2_1.sw_2.XM6.G 0.00133f
C701 DAC4_0.DAC3_1.DAC2_0.sw_1.vin1 li_6_5533# 0
C702 DAC4_1.DAC3_1.DAC2_0.sw_2.vin1 DAC4_1.DAC3_1.sw_0.XM6.G 0
C703 DAC4_0.DAC3_0.DAC2_1.vrefh li_8_10927# 0.03589f
C704 DAC4_1.DAC3_1.DAC2_0.sw_2.XM6.G b2 0
C705 DAC4_1.DAC3_1.DAC2_0.sw_2.XM8.G b2 0
C706 DAC4_1.DAC3_1.DAC2_1.sw_1.vin2 DAC4_1.DAC3_1.DAC2_1.sw_2.vin1 0.19226f
C707 DAC4_1.DAC3_1.DAC2_0.sw_1.XM6.G avdd 1.05416f
C708 DAC4_0.DAC3_0.DAC2_1.sw_0.XM8.G avdd 0.56244f
C709 b1 DAC4_1.sw_0.XM6.G 0
C710 DAC4_1.DAC3_1.sw_0.XM6.G DAC4_1.DAC3_1.sw_0.vin2 0.40444f
C711 b1 DAC4_0.DAC3_1.DAC2_0.sw_1.XM6.G 0
C712 DAC4_1.DAC3_1.DAC2_0.sw_2.vin1 DAC4_1.DAC3_1.DAC2_0.sw_0.XM8.G 0
C713 DAC4_1.DAC3_1.DAC2_0.sw_1.vin1 li_11371_7316# 0
C714 DAC4_0.sw_0.vin1 b2 0
C715 DAC4_1.DAC3_0.DAC2_1.sw_1.vin1 li_11369_4638# 0
C716 b3 DAC4_1.DAC3_0.DAC2_1.sw_2.XM6.G 0.0082f
C717 DAC4_0.DAC3_0.DAC2_1.sw_2.vin1 DAC4_0.sw_0.vin2 0
C718 DAC4_0.DAC3_1.DAC2_1.sw_2.vin2 avdd 0.72001f
C719 b0 li_6_1907# 0.02486f
C720 DAC4_0.DAC3_0.DAC2_1.sw_2.XM8.G b3 0
C721 DAC4_1.DAC3_1.DAC2_0.sw_1.vin1 DAC4_1.DAC3_1.DAC2_0.sw_0.XM8.G 0
C722 b1 DAC4_1.DAC3_0.DAC2_1.sw_0.vin1 0
C723 DAC4_1.DAC3_1.DAC2_0.sw_1.vin2 DAC4_1.DAC3_1.DAC2_0.sw_2.vin1 0.19198f
C724 DAC4_1.DAC3_0.DAC2_1.sw_1.vin2 DAC4_1.DAC3_0.DAC2_1.sw_0.XM6.G 0
C725 DAC4_1.DAC3_0.DAC2_1.sw_1.vin1 DAC4_1.DAC3_0.DAC2_1.sw_1.XM6.G 0.30012f
C726 DAC4_1.DAC3_0.DAC2_1.sw_1.vin1 DAC4_1.DAC3_0.sw_0.vin2 0
C727 DAC4_1.DAC3_1.DAC2_1.sw_1.XM8.G DAC4_1.DAC3_1.DAC2_1.sw_1.vin1 0.2606f
C728 DAC4_1.DAC3_0.DAC2_0.sw_0.XM8.G DAC4_1.DAC3_0.DAC2_1.sw_1.vin2 0
C729 b0 DAC4_1.vrefh 1.25383f
C730 DAC4_1.DAC3_0.DAC2_0.sw_0.XM8.G DAC4_1.DAC3_0.DAC2_0.sw_1.vin1 0
C731 DAC4_0.DAC3_1.DAC2_0.sw_2.XM8.G avdd 0.57069f
C732 DAC4_0.DAC3_1.DAC2_1.vrefh DAC4_0.DAC3_1.DAC2_0.sw_1.vin2 0.01211f
C733 DAC4_1.DAC3_1.DAC2_0.sw_1.vin2 DAC4_1.DAC3_1.DAC2_0.sw_1.vin1 0.18076f
C734 avdd DAC4_0.DAC3_1.DAC2_0.sw_0.XM6.G 1.05218f
C735 avdd li_11369_6458# 0.43318f
C736 DAC4_1.DAC3_1.DAC2_1.sw_1.XM8.G DAC4_1.DAC3_1.DAC2_1.sw_1.vin2 0.20368f
C737 DAC4_1.DAC3_1.DAC2_0.sw_0.vin1 DAC4_1.DAC3_1.DAC2_1.sw_1.vin2 0
C738 DAC4_0.sw_0.vin2 DAC4_0.DAC3_1.DAC2_0.sw_2.vin1 0.00632f
C739 DAC4_0.DAC3_0.DAC2_0.sw_2.XM8.G DAC4_0.DAC3_0.DAC2_0.sw_2.vin1 0.26061f
C740 DAC4_0.DAC3_0.DAC2_0.sw_0.XM6.G DAC4_0.DAC3_0.DAC2_1.sw_1.XM6.G 0
C741 DAC4_1.DAC3_0.sw_0.XM6.G DAC4_1.DAC3_0.sw_0.XM8.G 0.33977f
C742 DAC4_1.DAC3_0.DAC2_1.sw_1.XM8.G avdd 0.57719f
C743 DAC4_1.DAC3_1.DAC2_0.sw_2.vin1 DAC4_1.DAC3_1.DAC2_0.sw_2.vin2 0.18091f
C744 DAC4_0.DAC3_0.DAC2_0.sw_0.XM6.G DAC4_0.DAC3_0.DAC2_0.sw_0.XM8.G 0.33977f
C745 DAC4_0.DAC3_1.DAC2_1.sw_1.XM6.G DAC4_0.DAC3_1.DAC2_1.sw_1.XM8.G 0.33977f
C746 DAC4_1.DAC3_1.DAC2_0.sw_2.vin2 b3 0
C747 DAC4_1.DAC3_0.DAC2_0.sw_2.vin2 b2 0.39898f
C748 DAC4_1.DAC3_1.DAC2_1.vrefh b2 0.02529f
C749 DAC4_0.DAC3_1.DAC2_1.sw_1.vin2 DAC4_0.DAC3_1.DAC2_1.sw_1.XM8.G 0.20368f
C750 DAC4_1.DAC3_1.DAC2_0.sw_2.vin2 DAC4_1.DAC3_1.sw_0.vin2 0
C751 DAC4_1.sw_0.XM6.G DAC4_1.DAC3_1.DAC2_0.sw_2.vin1 0
C752 DAC4_1.DAC3_1.vrefh DAC4_1.DAC3_0.DAC2_1.sw_2.vin1 0.01454f
C753 li_8_9121# avdd 0.44052f
C754 DAC4_0.DAC3_0.DAC2_0.sw_0.vin1 avdd 0.71994f
C755 b1 DAC4_0.DAC3_0.DAC2_1.sw_2.XM6.G 0.12673f
C756 DAC4_0.DAC3_0.DAC2_0.sw_2.vin1 DAC4_0.DAC3_0.DAC2_0.sw_1.XM8.G 0.45122f
C757 DAC4_0.DAC3_0.DAC2_0.sw_1.vin2 DAC4_0.DAC3_0.DAC2_0.sw_1.vin1 0.18146f
C758 b0 DAC4_1.DAC3_0.DAC2_1.sw_2.vin1 0
C759 DAC4_1.sw_0.XM6.G b3 0.12757f
C760 DAC4_0.DAC3_0.sw_0.vin2 DAC4_0.sw_0.vin2 0.00969f
C761 b0 li_8_10031# 0.01593f
C762 li_11369_1012# DAC4_1.DAC3_0.DAC2_0.sw_1.XM6.G 0
C763 DAC4_1.DAC3_0.DAC2_0.sw_1.vin2 DAC4_1.DAC3_0.DAC2_0.sw_1.XM8.G 0.20368f
C764 DAC4_1.DAC3_1.DAC2_1.sw_1.XM8.G DAC4_1.DAC3_1.DAC2_1.sw_2.vin1 0.45122f
C765 b1 DAC4_0.DAC3_0.DAC2_0.sw_2.vin1 0.20146f
C766 DAC4_0.DAC3_1.sw_0.XM8.G avdd 0.56426f
C767 DAC4_0.DAC3_1.DAC2_0.sw_0.vin1 DAC4_0.DAC3_1.DAC2_0.sw_0.XM6.G 0.30012f
C768 DAC4_0.DAC3_1.DAC2_0.sw_1.XM8.G li_6_5533# 0
C769 avdd DAC4_1.DAC3_0.DAC2_0.sw_1.vin2 0.58137f
C770 b1 b2 5.63052f
C771 DAC4_0.DAC3_1.DAC2_1.sw_1.XM8.G DAC4_0.DAC3_1.DAC2_1.sw_1.vin1 0.2606f
C772 DAC4_0.DAC3_1.DAC2_0.sw_2.vin2 b0 0
C773 DAC4_0.DAC3_1.DAC2_1.sw_2.vin1 DAC4_0.DAC3_1.DAC2_1.sw_1.XM6.G 0.11006f
C774 DAC4_0.DAC3_1.DAC2_0.sw_1.XM8.G DAC4_0.DAC3_1.DAC2_0.sw_1.vin1 0.2606f
C775 DAC4_1.DAC3_0.DAC2_0.sw_2.XM6.G DAC4_1.DAC3_0.sw_0.XM8.G 0
C776 DAC4_0.DAC3_1.DAC2_1.sw_2.vin1 DAC4_0.DAC3_1.DAC2_1.sw_1.vin2 0.19198f
C777 DAC4_0.DAC3_0.DAC2_0.sw_0.XM6.G DAC4_0.DAC3_0.DAC2_0.sw_2.vin2 0.11009f
C778 DAC4_1.DAC3_0.DAC2_1.sw_1.XM8.G li_11369_4638# 0
C779 DAC4_1.DAC3_0.DAC2_0.sw_2.vin1 b2 0.21938f
C780 DAC4_1.DAC3_1.DAC2_1.sw_1.XM6.G avdd 1.05416f
C781 DAC4_0.sw_0.XM6.G DAC4_0.DAC3_0.DAC2_1.sw_2.XM6.G 0
C782 DAC4_0.DAC3_1.DAC2_1.sw_2.XM8.G avdd 0.56359f
C783 avdd DAC4_0.DAC3_0.sw_0.XM6.G 1.05262f
C784 b1 DAC4_1.DAC3_0.DAC2_1.sw_0.XM8.G 0.00175f
C785 DAC4_0.sw_0.vin1 sw_0.XM6.G 0.00148f
C786 b0 li_11371_9136# 0.01482f
C787 DAC4_0.DAC3_0.sw_0.vin2 DAC4_0.DAC3_0.DAC2_0.sw_2.XM6.G 0
C788 DAC4_0.DAC3_1.DAC2_1.sw_1.vin1 DAC4_0.DAC3_1.sw_0.vin2 0
C789 DAC4_0.DAC3_0.sw_0.vin1 DAC4_0.DAC3_0.DAC2_1.sw_2.vin1 0
C790 DAC4_1.DAC3_0.DAC2_1.sw_1.XM8.G DAC4_1.DAC3_0.sw_0.vin2 0
C791 DAC4_1.DAC3_0.DAC2_0.sw_0.vin1 DAC4_1.DAC3_0.DAC2_0.sw_2.vin2 0.27806f
C792 DAC4_0.DAC3_0.DAC2_1.sw_0.XM6.G avdd 1.0522f
C793 DAC4_0.DAC3_1.DAC2_1.sw_2.vin1 DAC4_0.DAC3_1.DAC2_1.sw_1.vin1 0.25815f
C794 DAC4_1.DAC3_0.DAC2_1.sw_1.XM8.G DAC4_1.DAC3_0.DAC2_1.sw_1.XM6.G 0.33977f
C795 DAC4_1.DAC3_1.DAC2_1.sw_1.XM8.G DAC4_1.DAC3_1.DAC2_0.sw_0.vin1 0
C796 DAC4_1.DAC3_1.DAC2_1.sw_1.vin1 DAC4_1.DAC3_1.DAC2_0.sw_0.XM8.G 0
C797 DAC4_1.DAC3_1.DAC2_0.sw_1.vin2 DAC4_1.DAC3_0.DAC2_1.sw_0.XM6.G 0
C798 DAC4_1.DAC3_1.DAC2_0.sw_0.XM8.G DAC4_1.DAC3_1.DAC2_1.sw_1.vin2 0
C799 DAC4_1.DAC3_0.DAC2_1.sw_2.XM8.G DAC4_1.DAC3_0.DAC2_1.sw_1.XM8.G 0
C800 DAC4_1.DAC3_1.DAC2_1.sw_2.XM6.G b2 0
C801 DAC4_0.DAC3_0.DAC2_1.sw_2.XM6.G b3 0
C802 DAC4_0.sw_0.vin1 DAC4_0.sw_0.XM8.G 0.261f
C803 DAC4_0.DAC3_0.DAC2_0.sw_0.vin1 li_8_11837# 0.02024f
C804 DAC4_1.DAC3_1.DAC2_0.sw_2.vin1 b2 0.21753f
C805 b1 DAC4_1.DAC3_0.DAC2_0.sw_0.vin1 0
C806 b3 b2 0
C807 b2 DAC4_1.DAC3_1.sw_0.vin2 0.15108f
C808 b1 DAC4_1.DAC3_0.DAC2_1.sw_2.vin2 0.32584f
C809 DAC4_1.DAC3_1.sw_0.XM6.G DAC4_1.DAC3_1.DAC2_1.sw_2.vin1 0
C810 b0 DAC4_0.DAC3_0.DAC2_1.sw_1.XM6.G 0.12643f
C811 DAC4_0.DAC3_1.DAC2_0.sw_2.vin2 DAC4_0.DAC3_1.DAC2_0.sw_2.XM6.G 0.40158f
C812 DAC4_0.DAC3_0.DAC2_0.sw_1.vin2 DAC4_0.DAC3_0.DAC2_0.sw_1.XM8.G 0.20368f
C813 DAC4_0.DAC3_1.DAC2_0.sw_1.XM8.G DAC4_0.DAC3_0.DAC2_1.sw_2.vin2 0
C814 DAC4_0.DAC3_1.DAC2_0.sw_2.vin2 DAC4_0.DAC3_1.DAC2_0.sw_0.XM8.G 0.46313f
C815 DAC4_1.DAC3_1.DAC2_0.sw_1.vin1 b2 0.02742f
C816 sw_0.XM8.G DAC4_0.DAC3_0.DAC2_1.sw_2.XM8.G 0
C817 DAC4_1.DAC3_1.DAC2_1.sw_0.XM8.G avdd 0.56218f
C818 b0 DAC4_0.DAC3_0.DAC2_0.sw_0.XM8.G 0
C819 DAC4_0.sw_0.vin1 DAC4_0.DAC3_0.DAC2_1.sw_2.vin1 0.00307f
C820 b0 DAC4_0.DAC3_1.vrefh 0.54671f
C821 DAC4_1.DAC3_1.DAC2_0.sw_0.XM8.G DAC4_1.DAC3_1.DAC2_1.sw_2.vin1 0
C822 b0 li_11369_3728# 0.01593f
C823 b1 DAC4_0.DAC3_0.DAC2_0.sw_1.vin2 0
C824 DAC4_1.DAC3_0.DAC2_1.sw_0.XM8.G DAC4_1.DAC3_1.DAC2_0.sw_2.vin1 0
C825 DAC4_1.DAC3_0.DAC2_0.sw_2.vin2 DAC4_1.DAC3_0.DAC2_0.sw_0.XM6.G 0.11009f
C826 DAC4_1.DAC3_1.DAC2_0.sw_2.vin2 DAC4_1.DAC3_1.DAC2_1.sw_1.vin2 0.00781f
C827 DAC4_1.DAC3_0.DAC2_1.sw_0.XM8.G b3 0
C828 DAC4_0.DAC3_0.sw_0.vin1 DAC4_0.DAC3_0.sw_0.vin2 0.20354f
C829 DAC4_1.DAC3_0.DAC2_1.sw_0.XM6.G DAC4_1.DAC3_0.DAC2_1.sw_0.vin1 0.30012f
C830 DAC4_0.DAC3_1.DAC2_1.vrefh avdd 0.63031f
C831 DAC4_1.DAC3_0.DAC2_1.sw_1.vin1 DAC4_1.DAC3_0.DAC2_1.sw_2.vin1 0.25815f
C832 DAC4_0.DAC3_1.DAC2_0.sw_2.vin2 DAC4_0.DAC3_1.sw_0.vin1 0.21091f
C833 DAC4_1.DAC3_1.DAC2_0.sw_1.vin1 DAC4_1.DAC3_0.DAC2_1.sw_0.XM8.G 0
C834 avdd li_6_3713# 0.4312f
C835 DAC4_0.sw_0.vin1 DAC4_0.DAC3_1.DAC2_0.sw_2.vin1 0
C836 DAC4_1.DAC3_0.DAC2_0.sw_1.XM6.G DAC4_1.DAC3_0.DAC2_0.sw_1.XM8.G 0.33977f
C837 DAC4_0.DAC3_1.sw_0.XM6.G avdd 1.05262f
C838 b1 DAC4_1.DAC3_0.DAC2_0.sw_0.XM6.G 0
C839 DAC4_0.DAC3_1.DAC2_0.sw_1.XM6.G li_6_5533# 0
C840 avdd DAC4_1.DAC3_0.DAC2_0.sw_1.XM6.G 1.05416f
C841 sw_0.XM8.G DAC4_1.DAC3_1.DAC2_0.sw_2.vin2 0
C842 DAC4_0.DAC3_1.DAC2_1.sw_1.XM8.G DAC4_0.DAC3_1.sw_0.vin2 0
C843 DAC4_0.DAC3_1.DAC2_1.sw_2.vin2 DAC4_1.vrefh 0.20536f
C844 b0 DAC4_0.DAC3_0.DAC2_0.sw_2.vin2 0
C845 DAC4_0.DAC3_1.DAC2_1.sw_2.vin1 DAC4_0.DAC3_1.DAC2_1.sw_1.XM8.G 0.45122f
C846 li_8_13657# avdd 0.32801f
C847 DAC4_0.DAC3_1.DAC2_0.sw_1.XM6.G DAC4_0.DAC3_1.DAC2_0.sw_1.vin1 0.30012f
C848 DAC4_1.DAC3_1.DAC2_1.sw_1.XM8.G DAC4_1.DAC3_1.DAC2_0.sw_0.XM8.G 0
C849 DAC4_1.DAC3_1.DAC2_0.sw_0.XM8.G DAC4_1.DAC3_1.DAC2_0.sw_0.vin1 0.2606f
C850 DAC4_1.DAC3_0.DAC2_0.sw_2.vin1 DAC4_1.DAC3_0.DAC2_0.sw_0.XM6.G 0
C851 DAC4_0.DAC3_0.DAC2_1.sw_0.vin1 DAC4_0.DAC3_0.DAC2_1.sw_1.XM6.G 0.00197f
C852 li_11371_10942# avdd 0.47745f
C853 DAC4_1.DAC3_0.DAC2_0.sw_2.XM8.G DAC4_1.DAC3_0.sw_0.XM6.G 0
C854 DAC4_0.DAC3_0.DAC2_1.sw_2.XM8.G DAC4_0.DAC3_0.DAC2_1.sw_2.vin2 0.20378f
C855 DAC4_0.DAC3_1.DAC2_0.sw_0.vin1 DAC4_0.DAC3_1.DAC2_1.vrefh 0.19196f
C856 DAC4_1.DAC3_0.DAC2_1.sw_2.vin2 b3 0.05731f
C857 DAC4_0.sw_0.vin1 DAC4_0.DAC3_0.sw_0.vin2 0.33436f
C858 DAC4_0.DAC3_0.DAC2_1.sw_0.vin1 DAC4_0.DAC3_1.vrefh 0.19196f
C859 DAC4_0.DAC3_1.DAC2_1.sw_2.XM6.G avdd 1.05172f
C860 DAC4_1.DAC3_1.DAC2_0.sw_1.vin2 DAC4_1.DAC3_1.DAC2_0.sw_0.vin1 0.02132f
C861 avdd DAC4_0.DAC3_1.DAC2_1.sw_0.XM6.G 1.05175f
C862 avdd vrefh 0.00134f
C863 b1 DAC4_0.DAC3_0.DAC2_1.sw_2.vin1 0.38231f
C864 DAC4_1.DAC3_0.DAC2_1.sw_0.XM6.G b2 0.00215f
C865 DAC4_0.DAC3_1.DAC2_1.sw_2.vin1 DAC4_0.DAC3_1.sw_0.vin2 0.2842f
C866 DAC4_1.DAC3_1.sw_0.vin1 avdd 1.69019f
C867 DAC4_0.sw_0.XM6.G DAC4_0.sw_0.XM8.G 0.33977f
C868 DAC4_1.DAC3_0.DAC2_0.sw_0.XM8.G b2 0.00948f
C869 DAC4_0.DAC3_1.DAC2_1.sw_1.XM6.G b2 0.00217f
C870 DAC4_1.DAC3_1.DAC2_1.sw_1.XM8.G DAC4_1.DAC3_1.DAC2_0.sw_2.vin2 0
C871 DAC4_1.DAC3_1.DAC2_0.sw_0.vin1 DAC4_1.DAC3_1.DAC2_0.sw_2.vin2 0.27819f
C872 DAC4_0.DAC3_0.DAC2_1.sw_2.vin2 DAC4_0.DAC3_0.DAC2_1.sw_1.XM8.G 0
C873 sw_0.XM6.G b3 0
C874 b0 li_11371_8226# 0.02486f
C875 avdd DAC4_0.DAC3_1.DAC2_1.sw_0.vin1 0.49944f
C876 DAC4_0.DAC3_1.DAC2_1.sw_1.vin2 b2 0.02853f
C877 DAC4_1.DAC3_0.DAC2_0.sw_2.XM8.G DAC4_1.DAC3_0.DAC2_0.sw_2.XM6.G 0.33977f
C878 DAC4_0.DAC3_0.DAC2_0.sw_2.XM8.G DAC4_0.DAC3_0.sw_0.vin2 0
C879 DAC4_1.DAC3_0.DAC2_1.sw_1.XM8.G DAC4_1.DAC3_0.DAC2_1.sw_2.vin1 0.45122f
C880 DAC4_1.DAC3_0.DAC2_0.sw_1.vin2 DAC4_1.vrefh 0
C881 DAC4_1.DAC3_0.DAC2_1.sw_0.XM6.G DAC4_1.DAC3_0.DAC2_1.sw_0.XM8.G 0.33977f
C882 b1 DAC4_0.DAC3_1.DAC2_0.sw_2.vin1 0.38049f
C883 DAC4_1.DAC3_1.DAC2_1.sw_2.vin2 b0 0
C884 DAC4_0.sw_0.XM6.G DAC4_0.DAC3_0.DAC2_1.sw_2.vin1 0
C885 avdd DAC4_0.sw_0.vin2 1.10635f
C886 DAC4_0.DAC3_1.DAC2_0.sw_2.vin2 DAC4_0.DAC3_1.DAC2_0.sw_2.XM8.G 0.20378f
C887 DAC4_0.DAC3_1.DAC2_0.sw_2.vin2 DAC4_0.DAC3_1.DAC2_0.sw_0.XM6.G 0.11009f
C888 DAC4_1.DAC3_0.DAC2_1.sw_1.vin1 li_11369_3728# 0
C889 DAC4_0.DAC3_1.DAC2_0.sw_1.XM6.G DAC4_0.DAC3_0.DAC2_1.sw_2.vin2 0
C890 b4 b3 0.00224f
C891 b0 DAC4_0.DAC3_0.DAC2_0.sw_0.XM6.G 0.12589f
C892 DAC4_0.DAC3_1.DAC2_1.sw_1.vin1 b2 0.02742f
C893 DAC4_1.DAC3_0.DAC2_0.sw_1.XM8.G DAC4_1.DAC3_0.DAC2_1.vrefh 0.0014f
C894 DAC4_0.sw_0.XM8.G b3 0.0033f
C895 DAC4_0.DAC3_1.DAC2_0.sw_1.vin1 b2 0.02742f
C896 avdd DAC4_1.DAC3_0.DAC2_1.vrefh 0.63021f
C897 DAC4_1.DAC3_1.sw_0.vin1 vout 0
C898 DAC4_1.DAC3_0.DAC2_1.sw_1.vin2 DAC4_1.DAC3_0.DAC2_1.sw_0.vin1 0.02132f
C899 DAC4_0.DAC3_1.DAC2_1.sw_2.XM8.G DAC4_1.vrefh 0
C900 DAC4_0.DAC3_0.DAC2_1.vrefh DAC4_0.DAC3_0.DAC2_1.sw_1.vin1 0.01177f
C901 DAC4_0.DAC3_0.DAC2_1.sw_1.XM8.G DAC4_0.DAC3_0.DAC2_1.sw_1.vin1 0.2606f
C902 DAC4_0.DAC3_0.DAC2_0.sw_1.XM6.G DAC4_0.DAC3_0.DAC2_0.sw_1.vin1 0.30012f
C903 DAC4_1.DAC3_1.sw_0.vin1 DAC4_1.sw_0.vin2 0.33768f
C904 b1 DAC4_0.DAC3_0.sw_0.vin2 0.05733f
C905 DAC4_0.sw_0.XM6.G DAC4_0.DAC3_1.DAC2_0.sw_2.vin1 0
C906 DAC4_0.DAC3_1.DAC2_0.sw_1.XM6.G DAC4_0.DAC3_1.DAC2_0.sw_1.XM8.G 0.33977f
C907 b2 DAC4_1.DAC3_1.DAC2_1.sw_2.vin1 0.00127f
C908 DAC4_0.DAC3_0.DAC2_1.sw_0.XM8.G DAC4_0.DAC3_0.DAC2_1.sw_1.XM6.G 0
C909 DAC4_0.DAC3_0.DAC2_1.sw_2.vin1 b3 0
C910 DAC4_1.DAC3_1.DAC2_1.sw_0.vin1 avdd 0.49945f
C911 DAC4_1.DAC3_1.DAC2_0.sw_1.XM8.G DAC4_1.DAC3_1.DAC2_0.sw_0.XM6.G 0
C912 li_11369_102# avdd 0.32801f
C913 DAC4_1.DAC3_1.DAC2_1.sw_1.vin1 li_11371_11852# 0
C914 DAC4_1.DAC3_0.DAC2_0.sw_0.XM8.G DAC4_1.DAC3_0.DAC2_0.sw_0.vin1 0.2606f
C915 avdd DAC4_0.DAC3_0.DAC2_0.sw_2.XM6.G 1.0527f
C916 DAC4_1.DAC3_0.DAC2_1.sw_0.XM6.G DAC4_1.DAC3_0.DAC2_1.sw_2.vin2 0.11009f
C917 b0 li_11369_1922# 0.01482f
C918 DAC4_0.DAC3_0.DAC2_1.sw_0.XM8.G DAC4_0.DAC3_1.vrefh 0.20379f
C919 li_11371_11852# DAC4_1.DAC3_1.DAC2_1.sw_1.vin2 0.02113f
C920 DAC4_1.DAC3_0.sw_0.XM6.G avdd 1.05262f
C921 b1 DAC4_0.DAC3_0.DAC2_1.sw_1.vin2 0
C922 DAC4_0.DAC3_0.DAC2_0.sw_1.vin1 li_8_12747# 0
C923 DAC4_1.DAC3_0.sw_0.vin1 DAC4_1.DAC3_0.sw_0.XM6.G 0.30206f
C924 DAC4_1.DAC3_1.DAC2_0.sw_2.vin2 DAC4_1.DAC3_1.sw_0.XM6.G 0
C925 DAC4_0.DAC3_0.sw_0.vin2 DAC4_0.sw_0.XM6.G 0
C926 DAC4_1.DAC3_1.sw_0.XM8.G avdd 0.56426f
C927 DAC4_0.DAC3_0.DAC2_1.sw_2.XM6.G DAC4_0.DAC3_0.DAC2_1.sw_2.vin2 0.40158f
C928 avdd li_11369_5548# 0.4768f
C929 b3 DAC4_0.DAC3_1.DAC2_0.sw_2.vin1 0.02634f
C930 DAC4_1.DAC3_1.DAC2_1.sw_2.vin2 li_11371_12762# 0
C931 DAC4_1.DAC3_1.DAC2_0.sw_0.XM8.G DAC4_1.DAC3_1.DAC2_0.sw_2.vin2 0.46313f
C932 DAC4_0.DAC3_0.DAC2_1.sw_2.XM8.G DAC4_0.DAC3_0.DAC2_1.sw_1.XM8.G 0
C933 DAC4_1.DAC3_1.DAC2_0.sw_0.vin1 b2 0.02314f
C934 avdd DAC4_0.DAC3_1.DAC2_1.sw_0.XM8.G 0.56218f
C935 DAC4_0.DAC3_0.DAC2_1.sw_2.vin2 b2 0.39842f
C936 DAC4_1.sw_0.XM6.G DAC4_1.DAC3_0.DAC2_1.sw_2.XM6.G 0
C937 li_11371_11852# DAC4_1.DAC3_1.DAC2_1.sw_2.vin1 0
C938 DAC4_1.DAC3_0.DAC2_1.sw_1.vin2 b2 0.02877f
C939 DAC4_1.DAC3_0.DAC2_0.sw_1.vin1 b2 0.02832f
C940 avdd DAC4_1.DAC3_1.DAC2_0.sw_0.XM6.G 1.05218f
C941 b1 DAC4_0.DAC3_1.DAC2_0.sw_1.vin2 0
C942 li_11371_13672# avdd 0.002f
C943 DAC4_1.DAC3_1.DAC2_0.sw_1.XM8.G DAC4_1.DAC3_1.DAC2_0.sw_2.XM8.G 0
C944 DAC4_1.DAC3_0.DAC2_0.sw_2.XM6.G DAC4_1.DAC3_0.DAC2_0.sw_1.XM8.G 0
C945 DAC4_1.DAC3_0.DAC2_1.sw_1.XM6.G DAC4_1.DAC3_0.DAC2_1.vrefh 0
C946 DAC4_1.DAC3_1.DAC2_0.sw_1.XM8.G DAC4_1.DAC3_1.DAC2_0.sw_2.XM6.G 0
C947 DAC4_1.sw_0.vin1 DAC4_1.DAC3_1.sw_0.vin1 0
C948 DAC4_1.DAC3_0.DAC2_0.sw_0.XM8.G DAC4_1.DAC3_0.DAC2_0.sw_0.XM6.G 0.33977f
C949 DAC4_1.DAC3_1.DAC2_1.sw_0.XM8.G DAC4_1.DAC3_1.DAC2_1.sw_2.XM8.G 0
C950 DAC4_1.DAC3_0.DAC2_0.sw_2.vin2 DAC4_1.DAC3_0.DAC2_0.sw_2.XM8.G 0.20378f
C951 DAC4_1.DAC3_0.DAC2_0.sw_2.XM6.G avdd 1.0527f
C952 li_8_9121# DAC4_0.DAC3_0.DAC2_1.sw_1.XM6.G 0
C953 DAC4_0.DAC3_1.DAC2_1.sw_1.XM8.G b2 0.01153f
C954 DAC4_1.DAC3_0.DAC2_0.sw_2.XM6.G DAC4_1.DAC3_0.sw_0.vin1 0.11216f
C955 DAC4_0.DAC3_1.DAC2_0.sw_1.XM8.G b2 0.01135f
C956 DAC4_0.DAC3_0.sw_0.vin1 avdd 1.69018f
C957 DAC4_0.DAC3_0.DAC2_0.sw_0.vin1 DAC4_0.DAC3_0.DAC2_0.sw_0.XM8.G 0.2606f
C958 DAC4_1.DAC3_1.sw_0.XM8.G DAC4_1.sw_0.vin2 0.4592f
C959 b0 DAC4_1.DAC3_1.vrefh 0.54671f
C960 DAC4_1.DAC3_0.DAC2_0.sw_1.XM6.G DAC4_1.vrefh 0
C961 DAC4_0.DAC3_0.DAC2_0.sw_1.XM6.G DAC4_0.DAC3_0.DAC2_0.sw_1.XM8.G 0.33977f
C962 DAC4_0.DAC3_0.DAC2_1.sw_1.vin1 b2 0.02765f
C963 DAC4_1.DAC3_1.sw_0.vin1 sw_0.vin2 0
C964 b1 DAC4_1.DAC3_0.DAC2_0.sw_2.XM8.G 0
C965 DAC4_1.DAC3_0.DAC2_0.sw_2.vin1 li_11369_1012# 0
C966 DAC4_1.DAC3_0.sw_0.XM6.G DAC4_1.DAC3_0.sw_0.vin2 0.40444f
C967 DAC4_1.DAC3_1.DAC2_0.sw_1.vin2 DAC4_1.DAC3_0.DAC2_1.sw_0.vin1 0
C968 b1 DAC4_0.DAC3_0.DAC2_0.sw_1.XM6.G 0
C969 sw_0.XM8.G sw_0.XM6.G 0.33977f
C970 DAC4_1.sw_0.XM6.G DAC4_1.DAC3_1.DAC2_0.sw_2.vin2 0
C971 DAC4_1.DAC3_1.DAC2_1.sw_1.XM8.G li_11371_11852# 0
C972 DAC4_0.DAC3_0.DAC2_0.sw_1.vin1 avdd 0.67681f
C973 DAC4_0.DAC3_1.sw_0.vin2 b2 0.15257f
C974 DAC4_1.DAC3_1.DAC2_0.sw_1.XM6.G li_11371_8226# 0
C975 DAC4_0.DAC3_1.DAC2_1.sw_2.vin1 b2 0.21904f
C976 DAC4_1.DAC3_0.DAC2_1.sw_2.XM8.G DAC4_1.DAC3_0.sw_0.XM6.G 0
C977 DAC4_1.DAC3_0.DAC2_0.sw_2.XM8.G DAC4_1.DAC3_0.DAC2_0.sw_2.vin1 0.26061f
C978 DAC4_1.DAC3_1.DAC2_0.sw_2.XM6.G avdd 1.05309f
C979 vrefl avdd 0.34712f
C980 DAC4_1.DAC3_1.DAC2_0.sw_2.XM8.G avdd 0.57069f
C981 DAC4_0.DAC3_1.DAC2_1.sw_2.XM6.G DAC4_1.vrefh 0
C982 DAC4_0.DAC3_1.DAC2_0.sw_2.vin2 DAC4_0.DAC3_1.DAC2_1.vrefh 0.2049f
C983 DAC4_1.vrefh DAC4_0.DAC3_1.DAC2_1.sw_0.XM6.G 0.40185f
C984 DAC4_1.DAC3_0.DAC2_0.sw_0.vin1 DAC4_1.DAC3_0.DAC2_1.sw_1.vin2 0
C985 DAC4_0.DAC3_0.DAC2_0.sw_1.XM8.G li_8_12747# 0
C986 DAC4_1.DAC3_0.DAC2_0.sw_0.vin1 DAC4_1.DAC3_0.DAC2_0.sw_1.vin1 0.00795f
C987 sw_0.XM8.G b4 0
C988 DAC4_1.DAC3_1.sw_0.XM6.G b2 0.12249f
C989 DAC4_0.DAC3_0.DAC2_1.sw_0.XM6.G DAC4_0.DAC3_0.DAC2_1.sw_1.XM6.G 0.00169f
C990 DAC4_0.DAC3_0.DAC2_0.sw_0.vin1 DAC4_0.DAC3_0.DAC2_0.sw_2.vin2 0.28105f
C991 sw_0.vin2 DAC4_0.sw_0.vin2 0
C992 DAC4_0.DAC3_0.DAC2_1.sw_2.XM6.G DAC4_0.DAC3_0.DAC2_1.sw_2.XM8.G 0.33977f
C993 DAC4_0.sw_0.vin1 avdd 1.48372f
C994 DAC4_1.DAC3_1.DAC2_0.sw_1.XM8.G DAC4_1.DAC3_1.DAC2_1.vrefh 0.0014f
C995 avdd DAC4_1.DAC3_1.DAC2_1.sw_0.XM6.G 1.05175f
C996 DAC4_0.DAC3_1.DAC2_0.sw_2.vin2 DAC4_0.DAC3_1.sw_0.XM6.G 0
C997 DAC4_0.DAC3_0.DAC2_1.sw_0.XM6.G DAC4_0.DAC3_1.vrefh 0.40159f
C998 DAC4_1.DAC3_1.DAC2_0.sw_0.XM8.G b2 0.00944f
C999 b2 DAC4_1.DAC3_0.DAC2_1.sw_2.XM6.G 0
C1000 DAC4_0.DAC3_0.DAC2_1.sw_2.XM8.G b2 0
C1001 DAC4_1.DAC3_0.DAC2_0.sw_2.XM6.G DAC4_1.DAC3_0.sw_0.vin2 0
C1002 DAC4_1.vrefh DAC4_0.DAC3_1.DAC2_1.sw_0.vin1 0.19372f
C1003 DAC4_1.sw_0.vin1 DAC4_1.DAC3_0.sw_0.XM6.G 0.11007f
C1004 sw_0.XM8.G DAC4_0.DAC3_0.DAC2_1.sw_2.vin1 0
C1005 DAC4_1.DAC3_1.sw_0.vin1 DAC4_1.DAC3_1.DAC2_1.sw_2.XM8.G 0
C1006 b1 DAC4_1.DAC3_1.DAC2_0.sw_1.XM8.G 0.00186f
C1007 b0 DAC4_0.DAC3_0.DAC2_1.sw_0.vin1 0.50813f
C1008 DAC4_1.DAC3_1.DAC2_0.sw_1.vin2 b2 0.02853f
C1009 b0 li_11371_12762# 0.05352f
C1010 b0 DAC4_0.DAC3_1.DAC2_0.sw_0.XM8.G 0
C1011 DAC4_1.DAC3_0.DAC2_1.sw_0.XM8.G DAC4_1.DAC3_0.DAC2_1.sw_2.XM6.G 0
C1012 DAC4_1.DAC3_1.DAC2_0.sw_2.XM8.G vout 0
C1013 li_6_5533# DAC4_0.DAC3_1.DAC2_0.sw_2.vin1 0
C1014 DAC4_0.DAC3_0.DAC2_1.sw_2.XM6.G DAC4_0.DAC3_0.DAC2_1.sw_1.XM8.G 0
C1015 DAC4_0.DAC3_0.sw_0.XM6.G DAC4_0.DAC3_0.DAC2_0.sw_2.vin2 0
C1016 DAC4_1.DAC3_1.DAC2_0.sw_2.XM6.G DAC4_1.sw_0.vin2 0.00128f
C1017 DAC4_0.DAC3_0.DAC2_0.sw_2.XM8.G avdd 0.57051f
C1018 DAC4_1.DAC3_1.DAC2_0.sw_2.XM8.G DAC4_1.sw_0.vin2 0.00806f
C1019 DAC4_1.DAC3_0.DAC2_0.sw_2.vin2 DAC4_1.DAC3_0.DAC2_0.sw_1.XM8.G 0
C1020 DAC4_1.DAC3_0.DAC2_1.sw_1.vin2 DAC4_1.DAC3_0.DAC2_0.sw_0.XM6.G 0
C1021 DAC4_0.DAC3_0.DAC2_1.vrefh DAC4_0.DAC3_0.DAC2_0.sw_2.vin1 0.01454f
C1022 DAC4_1.DAC3_0.DAC2_0.sw_1.vin1 DAC4_1.DAC3_0.DAC2_0.sw_0.XM6.G 0
C1023 DAC4_0.sw_0.vin1 vout 0
C1024 DAC4_1.DAC3_0.DAC2_0.sw_2.vin2 avdd 0.73887f
C1025 avdd DAC4_1.DAC3_1.DAC2_1.vrefh 0.63031f
C1026 DAC4_0.DAC3_1.DAC2_0.sw_1.vin1 DAC4_0.DAC3_1.DAC2_0.sw_2.vin1 0.25815f
C1027 DAC4_0.DAC3_0.DAC2_1.sw_1.XM8.G b2 0.01159f
C1028 DAC4_1.DAC3_1.DAC2_0.sw_2.vin2 b2 0.39869f
C1029 DAC4_1.DAC3_1.DAC2_0.sw_1.vin2 DAC4_1.DAC3_0.DAC2_1.sw_0.XM8.G 0
C1030 DAC4_1.DAC3_0.DAC2_0.sw_2.vin2 DAC4_1.DAC3_0.sw_0.vin1 0.21091f
C1031 DAC4_0.DAC3_0.DAC2_0.sw_1.XM8.G avdd 0.5772f
C1032 b1 DAC4_1.DAC3_0.DAC2_0.sw_1.XM8.G 0.0015f
C1033 DAC4_1.DAC3_0.DAC2_1.sw_1.vin1 DAC4_1.DAC3_1.vrefh 0
C1034 DAC4_0.DAC3_1.DAC2_0.sw_1.XM6.G b2 0.00217f
C1035 b0 DAC4_1.DAC3_0.DAC2_1.sw_1.vin1 0.35813f
C1036 DAC4_0.DAC3_0.DAC2_0.sw_0.vin1 DAC4_0.DAC3_0.DAC2_0.sw_0.XM6.G 0.30012f
C1037 b1 avdd 10.1319f
C1038 DAC4_1.DAC3_0.DAC2_1.sw_2.vin2 DAC4_1.DAC3_0.DAC2_1.sw_2.XM6.G 0.40158f
C1039 li_8_10927# avdd 0.4312f
C1040 DAC4_0.DAC3_0.DAC2_1.sw_2.vin1 DAC4_0.DAC3_0.DAC2_1.sw_2.vin2 0.18111f
C1041 DAC4_1.DAC3_0.DAC2_1.sw_0.vin1 b2 0.02331f
C1042 b1 DAC4_1.DAC3_0.sw_0.vin1 0.04728f
C1043 DAC4_0.DAC3_0.sw_0.vin2 sw_0.XM8.G 0
C1044 DAC4_1.DAC3_1.DAC2_0.sw_1.XM8.G DAC4_1.DAC3_1.DAC2_0.sw_2.vin1 0.4508f
C1045 DAC4_0.DAC3_1.DAC2_0.sw_2.vin2 DAC4_0.sw_0.vin2 0.00347f
C1046 DAC4_1.DAC3_0.DAC2_0.sw_2.vin1 DAC4_1.DAC3_0.DAC2_0.sw_1.XM8.G 0.45122f
C1047 DAC4_1.DAC3_0.DAC2_0.sw_2.vin1 avdd 0.7686f
C1048 DAC4_1.DAC3_1.DAC2_1.sw_2.vin2 DAC4_1.DAC3_1.DAC2_1.sw_1.XM6.G 0
C1049 DAC4_1.DAC3_1.DAC2_0.sw_1.XM8.G DAC4_1.DAC3_1.DAC2_0.sw_1.vin1 0.2606f
C1050 DAC4_1.DAC3_1.DAC2_0.sw_1.vin2 DAC4_1.DAC3_0.DAC2_1.sw_2.vin2 0.00798f
C1051 DAC4_1.DAC3_0.DAC2_0.sw_2.vin1 DAC4_1.DAC3_0.sw_0.vin1 0.26064f
C1052 DAC4_0.DAC3_1.DAC2_0.sw_2.XM6.G DAC4_0.DAC3_1.DAC2_0.sw_0.XM8.G 0
C1053 DAC4_1.vrefh DAC4_0.DAC3_1.DAC2_1.sw_0.XM8.G 0.20392f
C1054 DAC4_0.sw_0.XM6.G avdd 1.05396f
C1055 DAC4_1.sw_0.vin1 DAC4_1.DAC3_1.DAC2_0.sw_2.XM6.G 0
C1056 DAC4_1.DAC3_1.vrefh DAC4_1.DAC3_1.DAC2_0.sw_1.XM6.G 0
C1057 DAC4_1.sw_0.vin1 DAC4_1.DAC3_1.DAC2_0.sw_2.XM8.G 0
C1058 b0 DAC4_1.DAC3_1.DAC2_0.sw_1.XM6.G 0.12643f
C1059 DAC4_1.DAC3_0.DAC2_1.sw_0.XM8.G DAC4_1.DAC3_0.DAC2_1.sw_0.vin1 0.2606f
C1060 DAC4_1.DAC3_0.sw_0.XM6.G DAC4_1.DAC3_0.DAC2_1.sw_2.vin1 0
C1061 b1 DAC4_0.DAC3_1.DAC2_0.sw_0.vin1 0
C1062 DAC4_1.DAC3_1.sw_0.XM8.G DAC4_1.DAC3_1.DAC2_1.sw_2.XM8.G 0
C1063 b0 DAC4_0.DAC3_0.DAC2_1.sw_0.XM8.G 0
C1064 avdd li_11371_10046# 0.4312f
C1065 DAC4_0.DAC3_0.DAC2_1.sw_2.vin1 DAC4_0.DAC3_0.DAC2_1.sw_1.vin1 0.25815f
C1066 DAC4_1.DAC3_0.DAC2_0.sw_2.vin2 DAC4_1.DAC3_0.DAC2_1.sw_1.XM6.G 0
C1067 DAC4_1.DAC3_0.DAC2_0.sw_2.vin2 DAC4_1.DAC3_0.sw_0.vin2 0
C1068 li_8_8211# DAC4_0.DAC3_0.DAC2_1.sw_2.vin2 0
C1069 sw_0.vin1 DAC4_0.sw_0.vin2 0.19841f
C1070 li_6_5533# DAC4_0.DAC3_1.DAC2_0.sw_1.vin2 0.02113f
C1071 DAC4_1.DAC3_1.DAC2_1.sw_2.XM6.G avdd 1.05172f
C1072 b1 DAC4_1.sw_0.vin2 0.02386f
C1073 DAC4_0.DAC3_1.DAC2_0.sw_2.XM6.G DAC4_0.DAC3_1.sw_0.vin1 0.11216f
C1074 DAC4_1.DAC3_0.DAC2_0.sw_2.XM6.G DAC4_1.vrefh 0
C1075 DAC4_0.DAC3_0.DAC2_1.sw_2.XM6.G b2 0
C1076 b0 DAC4_0.DAC3_1.DAC2_1.sw_2.vin2 0.02826f
C1077 DAC4_0.DAC3_1.sw_0.vin1 DAC4_0.DAC3_1.DAC2_0.sw_0.XM8.G 0
C1078 DAC4_1.DAC3_1.DAC2_0.sw_2.vin1 avdd 0.77113f
C1079 DAC4_0.DAC3_0.DAC2_1.vrefh DAC4_0.DAC3_0.DAC2_0.sw_1.vin2 0.01211f
C1080 DAC4_1.DAC3_0.DAC2_0.sw_0.XM8.G DAC4_1.DAC3_0.DAC2_0.sw_2.XM8.G 0
C1081 DAC4_0.DAC3_1.DAC2_0.sw_1.XM8.G DAC4_0.DAC3_1.DAC2_0.sw_2.vin1 0.4508f
C1082 DAC4_0.DAC3_1.DAC2_0.sw_1.vin1 DAC4_0.DAC3_1.DAC2_0.sw_1.vin2 0.18076f
C1083 DAC4_0.DAC3_0.sw_0.vin2 DAC4_0.DAC3_0.DAC2_1.sw_2.vin2 0.22107f
C1084 avdd b3 2.01248f
C1085 DAC4_0.DAC3_0.DAC2_0.sw_2.vin1 b2 0
C1086 avdd DAC4_1.DAC3_1.sw_0.vin2 0.91f
C1087 b1 DAC4_1.DAC3_0.sw_0.vin2 0.05733f
C1088 DAC4_0.sw_0.XM8.G DAC4_0.DAC3_0.DAC2_1.sw_2.XM8.G 0
C1089 b1 DAC4_1.DAC3_0.DAC2_1.sw_1.XM6.G 0
C1090 DAC4_1.DAC3_1.DAC2_0.sw_1.vin1 avdd 0.67221f
C1091 DAC4_0.sw_0.vin1 sw_0.vin2 0.00959f
C1092 DAC4_1.DAC3_0.sw_0.XM8.G DAC4_1.DAC3_0.DAC2_1.sw_2.XM6.G 0
C1093 b0 DAC4_0.DAC3_1.DAC2_0.sw_0.XM6.G 0.12589f
C1094 DAC4_1.DAC3_1.vrefh li_11369_6458# 0.03589f
C1095 DAC4_1.DAC3_0.DAC2_1.sw_0.vin1 DAC4_1.DAC3_0.DAC2_1.sw_2.vin2 0.27806f
C1096 b0 li_11369_6458# 0.01256f
C1097 DAC4_1.DAC3_1.DAC2_1.sw_0.XM8.G DAC4_1.DAC3_1.DAC2_1.sw_2.vin2 0.46316f
C1098 DAC4_1.DAC3_0.DAC2_1.sw_1.XM8.G DAC4_1.DAC3_1.vrefh 0.0014f
C1099 b0 DAC4_1.DAC3_0.DAC2_1.sw_1.XM8.G 0
C1100 DAC4_1.DAC3_0.DAC2_1.sw_2.XM8.G b1 0
C1101 DAC4_1.DAC3_0.DAC2_0.sw_2.vin1 DAC4_1.DAC3_0.sw_0.vin2 0
C1102 DAC4_0.DAC3_1.sw_0.vin2 DAC4_0.DAC3_1.DAC2_0.sw_2.vin1 0
C1103 DAC4_0.DAC3_0.DAC2_1.sw_2.vin1 DAC4_0.DAC3_0.DAC2_1.sw_2.XM8.G 0.26061f
C1104 DAC4_1.DAC3_0.DAC2_1.sw_0.XM8.G b2 0.00948f
C1105 li_6_997# avdd 0.19011f
C1106 DAC4_0.DAC3_0.DAC2_1.sw_0.XM8.G DAC4_0.DAC3_0.DAC2_1.sw_0.vin1 0.2606f
C1107 DAC4_0.DAC3_1.DAC2_1.sw_1.vin1 li_6_2817# 0
C1108 b0 li_8_9121# 0.02486f
C1109 DAC4_0.DAC3_0.sw_0.vin2 DAC4_0.DAC3_0.DAC2_1.sw_1.vin1 0
C1110 b0 DAC4_0.DAC3_0.DAC2_0.sw_0.vin1 0.50703f
C1111 DAC4_1.DAC3_1.DAC2_0.sw_2.vin1 vout 0
C1112 DAC4_1.DAC3_1.DAC2_0.sw_2.vin1 DAC4_1.sw_0.vin2 0.01777f
C1113 li_11371_9136# DAC4_1.DAC3_1.DAC2_0.sw_0.XM6.G 0
C1114 b0 DAC4_1.DAC3_0.DAC2_0.sw_1.vin2 0.34049f
C1115 vrefl DAC4_1.DAC3_1.DAC2_1.sw_2.XM8.G 0
C1116 b1 DAC4_1.sw_0.vin1 0
C1117 DAC4_1.sw_0.vin2 b3 0.22266f
C1118 DAC4_0.DAC3_0.DAC2_1.sw_2.vin2 DAC4_0.DAC3_1.DAC2_0.sw_1.vin2 0.00798f
C1119 DAC4_0.DAC3_0.DAC2_0.sw_0.XM8.G DAC4_0.DAC3_0.DAC2_0.sw_2.XM6.G 0
C1120 DAC4_1.sw_0.vin2 DAC4_1.DAC3_1.sw_0.vin2 0.20264f
C1121 DAC4_1.DAC3_1.DAC2_0.sw_1.vin1 DAC4_1.sw_0.vin2 0
C1122 DAC4_0.DAC3_0.DAC2_1.sw_1.vin2 DAC4_0.DAC3_0.DAC2_1.sw_1.vin1 0.18076f
C1123 DAC4_1.DAC3_0.DAC2_0.sw_0.vin1 b2 0.02331f
C1124 DAC4_0.DAC3_0.DAC2_1.sw_2.vin1 DAC4_0.DAC3_0.DAC2_1.sw_1.XM8.G 0.45122f
C1125 b0 DAC4_1.DAC3_1.DAC2_1.sw_1.XM6.G 0.12643f
C1126 b3 DAC4_1.DAC3_0.sw_0.vin2 0.05323f
C1127 DAC4_1.DAC3_0.DAC2_1.sw_2.vin2 b2 0.39842f
C1128 DAC4_0.DAC3_1.DAC2_0.sw_2.XM6.G DAC4_0.DAC3_1.DAC2_0.sw_2.XM8.G 0.33977f
C1129 DAC4_0.DAC3_1.DAC2_0.sw_2.XM8.G DAC4_0.DAC3_1.DAC2_0.sw_0.XM8.G 0
C1130 b0 DAC4_0.DAC3_1.DAC2_1.sw_2.XM8.G 0
C1131 DAC4_0.DAC3_0.DAC2_0.sw_2.vin1 DAC4_0.DAC3_0.DAC2_0.sw_1.vin2 0.19227f
C1132 DAC4_0.DAC3_1.DAC2_0.sw_0.XM6.G DAC4_0.DAC3_1.DAC2_0.sw_0.XM8.G 0.33977f
C1133 li_11369_1012# DAC4_1.DAC3_0.DAC2_0.sw_1.vin1 0
C1134 DAC4_0.DAC3_1.DAC2_0.sw_1.XM8.G DAC4_0.DAC3_1.DAC2_0.sw_1.vin2 0.20368f
C1135 DAC4_0.DAC3_1.DAC2_1.sw_2.vin2 DAC4_0.DAC3_1.sw_0.vin1 0
C1136 DAC4_1.DAC3_0.DAC2_1.sw_2.XM8.G b3 0.00516f
C1137 DAC4_0.DAC3_0.sw_0.vin2 DAC4_0.DAC3_0.DAC2_1.sw_2.XM8.G 0.45928f
C1138 DAC4_0.DAC3_1.DAC2_0.sw_2.vin2 DAC4_0.sw_0.vin1 0
C1139 b0 DAC4_0.DAC3_0.DAC2_1.sw_0.XM6.G 0.12588f
C1140 DAC4_1.DAC3_0.DAC2_1.sw_0.XM6.G avdd 1.0522f
C1141 DAC4_1.DAC3_0.DAC2_0.sw_0.XM8.G DAC4_1.DAC3_0.DAC2_0.sw_1.XM8.G 0
C1142 DAC4_1.DAC3_1.DAC2_1.sw_2.vin2 DAC4_1.DAC3_1.sw_0.vin1 0
C1143 DAC4_0.DAC3_0.DAC2_0.sw_2.XM6.G DAC4_0.DAC3_0.DAC2_0.sw_2.vin2 0.40158f
C1144 DAC4_1.DAC3_0.DAC2_0.sw_0.XM8.G avdd 0.56264f
C1145 DAC4_1.DAC3_0.DAC2_1.sw_0.XM8.G DAC4_1.DAC3_0.DAC2_1.sw_2.vin2 0.46313f
C1146 DAC4_0.DAC3_1.DAC2_0.sw_2.XM8.G DAC4_0.DAC3_1.sw_0.vin1 0.45396f
C1147 DAC4_0.DAC3_1.DAC2_1.sw_1.XM6.G avdd 1.05416f
C1148 DAC4_1.DAC3_0.DAC2_0.sw_0.XM8.G DAC4_1.DAC3_0.sw_0.vin1 0
C1149 DAC4_1.DAC3_1.DAC2_1.sw_1.vin1 avdd 0.67438f
C1150 DAC4_0.DAC3_1.DAC2_1.sw_1.vin2 avdd 0.57664f
C1151 DAC4_1.sw_0.vin1 DAC4_1.DAC3_1.DAC2_0.sw_2.vin1 0
C1152 DAC4_0.DAC3_1.DAC2_0.sw_1.XM6.G DAC4_0.DAC3_1.DAC2_0.sw_2.vin1 0.11006f
C1153 avdd DAC4_1.DAC3_1.DAC2_1.sw_1.vin2 0.57893f
C1154 DAC4_0.DAC3_1.sw_0.XM8.G DAC4_0.DAC3_1.DAC2_0.sw_2.XM6.G 0
C1155 b1 DAC4_1.vrefh 0.01558f
C1156 b2 DAC4_1.DAC3_0.DAC2_0.sw_0.XM6.G 0.00215f
C1157 DAC4_0.DAC3_0.sw_0.vin1 DAC4_0.DAC3_0.DAC2_0.sw_0.XM8.G 0
C1158 DAC4_1.sw_0.vin1 b3 1.68954f
C1159 avdd li_6_5533# 0.44133f
C1160 DAC4_1.DAC3_0.DAC2_1.sw_1.XM8.G DAC4_1.DAC3_0.DAC2_1.sw_1.vin1 0.2606f
C1161 DAC4_0.DAC3_0.sw_0.vin2 DAC4_0.DAC3_0.DAC2_1.sw_1.XM8.G 0
C1162 DAC4_1.DAC3_1.DAC2_1.sw_0.XM8.G b0 0
C1163 DAC4_0.DAC3_1.DAC2_1.sw_1.vin1 avdd 0.67231f
C1164 DAC4_0.sw_0.vin1 sw_0.vin1 0.27226f
C1165 DAC4_1.DAC3_0.DAC2_0.sw_2.vin1 DAC4_1.vrefh 0
C1166 DAC4_0.DAC3_1.DAC2_0.sw_1.vin1 avdd 0.67221f
C1167 b1 DAC4_1.DAC3_1.DAC2_1.sw_2.XM8.G 0
C1168 sw_0.XM8.G avdd 0.56388f
C1169 DAC4_0.DAC3_1.sw_0.XM8.G DAC4_0.DAC3_1.sw_0.vin1 0.26095f
C1170 DAC4_1.DAC3_0.sw_0.XM8.G b2 0
C1171 DAC4_1.DAC3_1.DAC2_0.sw_1.XM8.G DAC4_1.DAC3_1.DAC2_0.sw_0.vin1 0
C1172 DAC4_0.DAC3_0.DAC2_0.sw_1.vin1 DAC4_0.DAC3_0.DAC2_0.sw_0.XM8.G 0
C1173 DAC4_0.DAC3_0.DAC2_1.sw_2.vin1 DAC4_0.DAC3_0.DAC2_1.sw_2.XM6.G 0.30016f
C1174 b0 DAC4_0.DAC3_1.DAC2_1.vrefh 0.54824f
C1175 avdd DAC4_1.DAC3_1.DAC2_1.sw_2.vin1 0.75305f
C1176 sw_0.vin2 b3 0.01151f
C1177 DAC4_0.DAC3_1.DAC2_1.sw_1.vin2 DAC4_0.DAC3_1.DAC2_0.sw_0.vin1 0
C1178 DAC4_0.DAC3_0.DAC2_1.vrefh DAC4_0.DAC3_0.DAC2_1.sw_1.vin2 0.00538f
C1179 b1 DAC4_1.DAC3_0.DAC2_1.sw_2.vin1 0.38231f
C1180 DAC4_0.DAC3_0.DAC2_1.sw_0.XM6.G DAC4_0.DAC3_0.DAC2_1.sw_0.vin1 0.30012f
C1181 DAC4_0.DAC3_0.DAC2_1.sw_1.vin2 DAC4_0.DAC3_0.DAC2_1.sw_1.XM8.G 0.20368f
C1182 b0 li_6_3713# 0.01165f
C1183 DAC4_0.DAC3_0.DAC2_1.sw_2.vin1 b2 0.21786f
C1184 DAC4_1.DAC3_1.DAC2_1.sw_0.vin1 DAC4_1.DAC3_1.DAC2_1.sw_2.vin2 0.28122f
C1185 DAC4_1.DAC3_0.DAC2_1.sw_1.XM6.G DAC4_1.DAC3_0.DAC2_1.sw_0.XM6.G 0.00169f
C1186 DAC4_0.DAC3_0.sw_0.vin1 DAC4_0.DAC3_0.DAC2_0.sw_2.vin2 0.21091f
C1187 li_11371_9136# DAC4_1.DAC3_1.DAC2_1.vrefh 0
C1188 b0 DAC4_1.DAC3_0.DAC2_0.sw_1.XM6.G 0.12838f
C1189 DAC4_0.DAC3_1.DAC2_0.sw_2.vin2 b1 0.32859f
C1190 DAC4_1.DAC3_0.DAC2_0.sw_0.XM8.G DAC4_1.DAC3_0.DAC2_1.sw_1.XM6.G 0
C1191 DAC4_0.DAC3_1.DAC2_1.sw_2.XM8.G DAC4_0.DAC3_1.sw_0.vin1 0
C1192 DAC4_0.DAC3_1.DAC2_0.sw_1.vin1 DAC4_0.DAC3_1.DAC2_0.sw_0.vin1 0.00795f
C1193 DAC4_1.DAC3_0.DAC2_0.sw_0.vin1 DAC4_1.DAC3_0.DAC2_0.sw_0.XM6.G 0.30012f
C1194 li_11369_2832# avdd 0.4312f
C1195 b0 li_8_13657# 0
C1196 b0 li_11371_10942# 0.01593f
C1197 li_11369_1922# DAC4_1.DAC3_0.DAC2_1.vrefh 0
C1198 DAC4_1.DAC3_1.DAC2_1.sw_2.vin2 DAC4_1.DAC3_1.sw_0.XM8.G 0
C1199 DAC4_1.DAC3_1.DAC2_0.sw_2.XM8.G DAC4_1.sw_0.XM8.G 0
C1200 sw_0.XM8.G vout 0.44748f
C1201 DAC4_0.DAC3_0.DAC2_0.sw_1.vin1 DAC4_0.DAC3_0.DAC2_0.sw_2.vin2 0
C1202 b2 DAC4_0.DAC3_1.DAC2_0.sw_2.vin1 0.21753f
C1203 sw_0.XM8.G DAC4_1.sw_0.vin2 0
C1204 DAC4_1.DAC3_1.DAC2_1.sw_2.XM6.G DAC4_1.DAC3_1.DAC2_1.sw_2.XM8.G 0.33977f
C1205 DAC4_1.DAC3_1.DAC2_1.sw_1.XM8.G avdd 0.57719f
C1206 DAC4_1.DAC3_1.DAC2_0.sw_0.vin1 avdd 0.71993f
C1207 b0 DAC4_0.DAC3_1.DAC2_1.sw_2.XM6.G 0
C1208 DAC4_1.DAC3_0.DAC2_0.sw_1.vin1 DAC4_1.DAC3_0.DAC2_0.sw_1.XM8.G 0.2606f
C1209 b0 DAC4_0.DAC3_1.DAC2_1.sw_0.XM6.G 0.12989f
C1210 avdd DAC4_0.DAC3_0.DAC2_1.sw_2.vin2 0.73611f
C1211 DAC4_0.DAC3_1.DAC2_0.sw_1.XM6.G DAC4_0.DAC3_1.DAC2_0.sw_1.vin2 0.40155f
C1212 DAC4_1.DAC3_1.DAC2_1.sw_0.XM8.G li_11371_12762# 0
C1213 DAC4_1.DAC3_0.DAC2_1.sw_1.vin2 avdd 0.57892f
C1214 DAC4_0.DAC3_0.sw_0.vin2 DAC4_0.DAC3_0.DAC2_1.sw_2.XM6.G 0.11125f
C1215 avdd DAC4_1.DAC3_0.DAC2_0.sw_1.vin1 0.67089f
C1216 DAC4_1.DAC3_1.DAC2_1.sw_2.XM8.G DAC4_1.DAC3_1.sw_0.vin2 0.45928f
C1217 DAC4_1.DAC3_1.DAC2_1.sw_2.vin2 li_11371_13672# 0
C1218 DAC4_0.DAC3_0.DAC2_0.sw_2.XM8.G DAC4_0.DAC3_0.DAC2_0.sw_0.XM8.G 0
C1219 DAC4_0.DAC3_0.DAC2_0.sw_2.vin1 DAC4_0.DAC3_0.sw_0.vin2 0
C1220 DAC4_1.DAC3_0.DAC2_1.sw_2.vin2 DAC4_1.DAC3_0.sw_0.XM8.G 0
C1221 DAC4_0.DAC3_1.sw_0.XM8.G DAC4_0.DAC3_1.DAC2_1.sw_2.vin2 0
C1222 li_6_997# DAC4_1.vrefh 0
C1223 DAC4_0.DAC3_1.DAC2_1.sw_1.XM8.G avdd 0.57719f
C1224 DAC4_0.DAC3_0.sw_0.XM6.G DAC4_0.DAC3_0.sw_0.XM8.G 0.33977f
C1225 b3 DAC4_1.DAC3_0.DAC2_1.sw_2.vin1 0.0028f
C1226 DAC4_0.DAC3_1.DAC2_1.vrefh DAC4_0.DAC3_1.DAC2_0.sw_0.XM8.G 0.20379f
C1227 DAC4_0.DAC3_0.sw_0.vin2 b2 0.15143f
C1228 DAC4_0.DAC3_0.DAC2_1.vrefh DAC4_0.DAC3_0.DAC2_0.sw_1.XM6.G 0.00122f
C1229 DAC4_0.DAC3_1.DAC2_0.sw_1.XM8.G avdd 0.57659f
C1230 b0 DAC4_0.DAC3_1.DAC2_1.sw_0.vin1 0.52106f
C1231 DAC4_0.DAC3_0.DAC2_0.sw_1.XM8.G DAC4_0.DAC3_0.DAC2_0.sw_0.XM8.G 0
C1232 DAC4_0.DAC3_1.sw_0.XM6.G DAC4_0.DAC3_1.DAC2_0.sw_2.XM6.G 0
C1233 sw_0.XM6.G b4 0.12249f
C1234 DAC4_0.DAC3_1.sw_0.XM8.G DAC4_0.DAC3_1.DAC2_0.sw_2.XM8.G 0
C1235 b1 DAC4_0.DAC3_0.DAC2_1.sw_1.XM6.G 0
C1236 DAC4_1.DAC3_1.DAC2_0.sw_1.XM8.G DAC4_1.DAC3_1.DAC2_0.sw_0.XM8.G 0
C1237 DAC4_0.DAC3_1.DAC2_0.sw_2.vin2 b3 0.05035f
C1238 avdd DAC4_0.DAC3_0.DAC2_1.sw_1.vin1 0.67222f
C1239 DAC4_0.sw_0.XM6.G sw_0.vin1 0.1101f
C1240 DAC4_0.DAC3_0.DAC2_1.sw_0.XM6.G DAC4_0.DAC3_0.DAC2_1.sw_0.XM8.G 0.33977f
C1241 b1 DAC4_0.DAC3_0.DAC2_0.sw_0.XM8.G 0.00462f
C1242 b1 DAC4_0.DAC3_1.vrefh 0
C1243 DAC4_0.DAC3_0.DAC2_1.sw_1.vin2 b2 0.02877f
C1244 DAC4_0.DAC3_1.DAC2_1.sw_2.XM8.G DAC4_0.DAC3_1.DAC2_1.sw_2.vin2 0.20378f
C1245 DAC4_0.DAC3_1.DAC2_0.sw_1.vin1 li_6_6443# 0
C1246 avdd DAC4_0.DAC3_1.sw_0.vin2 0.90999f
C1247 DAC4_1.DAC3_1.DAC2_0.sw_1.vin2 DAC4_1.DAC3_1.DAC2_0.sw_1.XM8.G 0.20368f
C1248 DAC4_1.DAC3_0.DAC2_1.sw_1.vin2 li_11369_4638# 0.02113f
C1249 DAC4_0.DAC3_0.DAC2_0.sw_2.XM8.G DAC4_0.DAC3_0.DAC2_0.sw_2.vin2 0.20378f
C1250 DAC4_0.DAC3_1.DAC2_1.sw_2.vin1 avdd 0.75305f
C1251 b0 DAC4_1.DAC3_0.DAC2_1.vrefh 0.54824f
C1252 DAC4_0.DAC3_1.DAC2_1.sw_1.XM8.G DAC4_0.DAC3_1.DAC2_0.sw_0.vin1 0
C1253 DAC4_0.sw_0.XM8.G b4 0
C1254 DAC4_0.DAC3_1.sw_0.XM6.G DAC4_0.DAC3_1.sw_0.vin1 0.30206f
C1255 DAC4_0.DAC3_0.DAC2_0.sw_1.vin1 DAC4_0.DAC3_0.DAC2_0.sw_0.XM6.G 0
C1256 DAC4_1.DAC3_1.DAC2_1.sw_2.vin2 vrefl 0.21323f
C1257 DAC4_0.DAC3_1.DAC2_0.sw_1.XM8.G DAC4_0.DAC3_1.DAC2_0.sw_0.vin1 0
C1258 avdd li_11371_7316# 0.4761f
C1259 DAC4_0.DAC3_1.DAC2_1.sw_1.XM6.G li_6_1907# 0
C1260 avdd DAC4_1.DAC3_1.sw_0.XM6.G 1.05262f
C1261 b1 DAC4_1.sw_0.XM8.G 0
C1262 DAC4_1.DAC3_0.DAC2_1.sw_1.vin2 DAC4_1.DAC3_0.DAC2_1.sw_1.XM6.G 0.40155f
C1263 DAC4_1.DAC3_1.DAC2_0.sw_1.XM8.G DAC4_1.DAC3_1.DAC2_0.sw_2.vin2 0
C1264 b2 DAC4_0.DAC3_1.DAC2_0.sw_1.vin2 0.02853f
C1265 DAC4_0.DAC3_1.DAC2_1.sw_1.vin2 li_6_1907# 0.02113f
C1266 sw_0.vin1 b3 0.046f
C1267 DAC4_1.DAC3_1.DAC2_1.sw_0.vin1 b0 0.44622f
C1268 DAC4_0.DAC3_0.DAC2_0.sw_1.XM8.G DAC4_0.DAC3_0.DAC2_0.sw_2.vin2 0
C1269 b0 li_11369_102# 0.0415f
C1270 avdd DAC4_1.DAC3_0.DAC2_1.sw_2.XM6.G 1.05322f
C1271 DAC4_1.DAC3_1.DAC2_0.sw_0.XM8.G avdd 0.56264f
C1272 DAC4_1.DAC3_1.DAC2_1.sw_2.vin2 DAC4_1.DAC3_1.DAC2_1.sw_0.XM6.G 0.11009f
C1273 avdd DAC4_0.DAC3_0.DAC2_1.sw_2.XM8.G 0.5654f
C1274 DAC4_0.DAC3_1.DAC2_1.sw_1.XM6.G DAC4_1.vrefh 0.00122f
C1275 b1 DAC4_0.DAC3_0.DAC2_0.sw_2.vin2 0.35187f
C1276 sw_0.XM8.G sw_0.vin2 0.20379f
C1277 DAC4_1.DAC3_0.sw_0.vin1 DAC4_1.DAC3_0.DAC2_1.sw_2.XM6.G 0
C1278 DAC4_0.DAC3_1.DAC2_1.sw_2.XM6.G DAC4_0.DAC3_1.sw_0.vin1 0
C1279 DAC4_0.DAC3_1.DAC2_1.sw_1.vin2 DAC4_1.vrefh 0.01211f
C1280 DAC4_0.DAC3_1.DAC2_1.sw_1.vin1 li_6_1907# 0
C1281 DAC4_1.DAC3_1.vrefh li_11369_5548# 0
C1282 DAC4_1.DAC3_1.DAC2_0.sw_1.vin2 avdd 0.58035f
C1283 b0 li_11369_5548# 0.0158f
C1284 DAC4_0.DAC3_1.sw_0.XM8.G DAC4_0.DAC3_1.DAC2_1.sw_2.XM8.G 0
C1285 DAC4_1.DAC3_1.DAC2_0.sw_1.XM8.G DAC4_1.DAC3_0.DAC2_1.sw_0.vin1 0
C1286 DAC4_1.DAC3_0.DAC2_1.sw_0.XM6.G DAC4_1.DAC3_0.DAC2_1.sw_2.vin1 0
C1287 DAC4_0.DAC3_1.DAC2_0.sw_2.XM6.G DAC4_0.sw_0.vin2 0
C1288 DAC4_0.DAC3_0.DAC2_0.sw_2.vin1 DAC4_0.DAC3_0.DAC2_0.sw_1.XM6.G 0.11007f
C1289 DAC4_1.DAC3_0.DAC2_0.sw_2.XM8.G b2 0
C1290 b0 DAC4_0.DAC3_1.DAC2_1.sw_0.XM8.G 0.00299f
C1291 DAC4_0.DAC3_1.DAC2_1.sw_1.vin1 DAC4_1.vrefh 0
C1292 DAC4_1.DAC3_0.DAC2_0.sw_0.XM8.G DAC4_1.DAC3_0.DAC2_1.sw_2.vin1 0
C1293 DAC4_0.DAC3_0.DAC2_1.vrefh avdd 0.63172f
C1294 DAC4_1.sw_0.vin2 DAC4_1.DAC3_1.sw_0.XM6.G 0.1101f
C1295 li_6_87# avdd 0.002f
C1296 avdd DAC4_0.DAC3_0.DAC2_1.sw_1.XM8.G 0.57719f
C1297 b0 DAC4_1.DAC3_1.DAC2_0.sw_0.XM6.G 0.12589f
C1298 DAC4_1.DAC3_1.DAC2_0.sw_2.vin2 avdd 0.73887f
C1299 b0 li_11371_13672# 0
C1300 DAC4_0.DAC3_1.sw_0.XM6.G DAC4_0.DAC3_1.DAC2_1.sw_2.vin2 0
C1301 DAC4_0.DAC3_0.DAC2_1.sw_2.XM8.G vout 0
C1302 DAC4_0.DAC3_1.DAC2_1.vrefh DAC4_0.DAC3_1.DAC2_0.sw_0.XM6.G 0.40159f
C1303 DAC4_0.DAC3_1.DAC2_0.sw_2.vin2 DAC4_0.DAC3_1.DAC2_1.sw_1.XM6.G 0
C1304 b0 DAC4_1.DAC3_0.DAC2_0.sw_2.XM6.G 0
C1305 DAC4_1.sw_0.XM6.G avdd 1.05388f
C1306 DAC4_0.DAC3_1.sw_0.vin1 DAC4_0.sw_0.vin2 0.3375f
C1307 DAC4_0.DAC3_0.DAC2_0.sw_2.vin1 li_8_12747# 0
C1308 DAC4_1.sw_0.XM8.G b3 0
C1309 DAC4_0.DAC3_1.DAC2_0.sw_1.XM6.G avdd 1.05416f
C1310 DAC4_0.DAC3_1.DAC2_1.sw_1.vin2 DAC4_0.DAC3_1.DAC2_0.sw_2.vin2 0.00781f
C1311 DAC4_1.DAC3_1.DAC2_1.sw_0.vin1 li_11371_12762# 0.07492f
C1312 DAC4_1.DAC3_1.DAC2_1.sw_2.vin2 b1 0.16567f
C1313 DAC4_0.DAC3_1.sw_0.XM6.G DAC4_0.DAC3_1.DAC2_0.sw_2.XM8.G 0
C1314 DAC4_0.DAC3_0.DAC2_0.sw_1.XM8.G DAC4_0.DAC3_0.DAC2_0.sw_0.XM6.G 0
C1315 DAC4_1.DAC3_0.sw_0.vin2 DAC4_1.DAC3_0.DAC2_1.sw_2.XM6.G 0.11125f
C1316 DAC4_1.DAC3_0.DAC2_1.sw_0.vin1 avdd 0.72828f
C1317 DAC4_1.DAC3_1.DAC2_1.sw_2.XM8.G DAC4_1.DAC3_1.DAC2_1.sw_2.vin1 0.26061f
C1318 b1 DAC4_0.DAC3_0.DAC2_0.sw_0.XM6.G 0.00134f
C1319 DAC4_0.DAC3_1.DAC2_1.sw_2.XM6.G DAC4_0.DAC3_1.DAC2_1.sw_2.vin2 0.40158f
C1320 DAC4_1.DAC3_0.DAC2_1.sw_1.vin1 DAC4_1.DAC3_0.DAC2_1.vrefh 0.01177f
C1321 DAC4_1.DAC3_0.DAC2_0.sw_2.vin2 li_11369_1922# 0
C1322 DAC4_0.DAC3_1.DAC2_1.sw_2.vin2 DAC4_0.DAC3_1.DAC2_1.sw_0.XM6.G 0.11009f
C1323 DAC4_1.DAC3_0.DAC2_1.sw_2.XM8.G DAC4_1.DAC3_0.DAC2_1.sw_2.XM6.G 0.33977f
C1324 DAC4_1.DAC3_1.DAC2_0.sw_1.XM8.G b2 0.01135f
C1325 b0 DAC4_0.DAC3_0.DAC2_0.sw_1.vin1 0.21999f
C1326 DAC4_0.DAC3_0.sw_0.vin2 DAC4_0.DAC3_0.DAC2_1.sw_2.vin1 0.2842f
C1327 DAC4_1.DAC3_1.DAC2_0.sw_2.vin2 vout 0.00293f
C1328 DAC4_1.DAC3_1.DAC2_1.sw_0.XM8.G DAC4_1.DAC3_1.DAC2_1.sw_1.XM6.G 0
C1329 DAC4_1.DAC3_1.DAC2_0.sw_2.vin2 DAC4_1.sw_0.vin2 0.03203f
C1330 vrefl b0 0.16206f
C1331 DAC4_0.DAC3_1.DAC2_0.sw_1.XM6.G DAC4_0.DAC3_1.DAC2_0.sw_0.vin1 0.00197f
C1332 DAC4_0.DAC3_1.DAC2_1.sw_1.XM8.G li_6_1907# 0
C1333 DAC4_1.DAC3_0.DAC2_0.sw_1.vin1 DAC4_1.vrefh 0.0048f
C1334 DAC4_1.sw_0.XM6.G DAC4_1.sw_0.vin2 0.4025f
C1335 DAC4_0.DAC3_1.sw_0.XM6.G DAC4_0.DAC3_1.sw_0.XM8.G 0.33977f
C1336 DAC4_1.DAC3_1.DAC2_0.sw_1.XM8.G DAC4_1.DAC3_0.DAC2_1.sw_0.XM8.G 0
C1337 DAC4_1.DAC3_1.DAC2_0.sw_2.vin1 li_11371_8226# 0
C1338 DAC4_0.DAC3_1.DAC2_1.sw_2.vin2 DAC4_0.DAC3_1.DAC2_1.sw_0.vin1 0.2782f
C1339 DAC4_0.DAC3_0.DAC2_1.vrefh li_8_11837# 0
C1340 DAC4_0.DAC3_0.DAC2_0.sw_1.vin2 DAC4_0.DAC3_0.DAC2_0.sw_1.XM6.G 0.40155f
C1341 DAC4_1.DAC3_0.DAC2_0.sw_1.XM6.G DAC4_1.DAC3_0.DAC2_0.sw_1.vin2 0.40155f
C1342 b0 DAC4_1.DAC3_1.DAC2_1.sw_0.XM6.G 0.12424f
C1343 DAC4_0.DAC3_0.DAC2_1.sw_2.vin1 DAC4_0.DAC3_0.DAC2_1.sw_1.vin2 0.19197f
C1344 DAC4_1.DAC3_1.DAC2_1.sw_1.XM8.G DAC4_1.DAC3_1.DAC2_1.sw_2.XM8.G 0
C1345 DAC4_1.sw_0.vin1 DAC4_1.DAC3_0.DAC2_1.sw_2.XM6.G 0
C1346 DAC4_0.DAC3_1.DAC2_1.sw_1.XM8.G DAC4_1.vrefh 0.0014f
C1347 DAC4_1.DAC3_1.DAC2_1.sw_2.vin2 DAC4_1.DAC3_1.DAC2_1.sw_2.XM6.G 0.40158f
C1348 avdd DAC4_0.DAC3_0.DAC2_1.sw_2.XM6.G 1.05322f
C1349 DAC4_1.sw_0.XM6.G DAC4_1.DAC3_0.sw_0.vin2 0
C1350 DAC4_0.DAC3_1.DAC2_1.sw_2.vin2 DAC4_0.sw_0.vin2 0.00324f
C1351 DAC4_1.DAC3_0.DAC2_0.sw_1.XM8.G b2 0.01074f
C1352 DAC4_1.DAC3_1.DAC2_0.sw_1.vin1 li_11371_8226# 0
C1353 DAC4_0.DAC3_0.DAC2_0.sw_2.vin1 avdd 0.77304f
C1354 sw_0.XM8.G sw_0.vin1 0.2606f
C1355 avdd b2 6.82137f
C1356 DAC4_1.DAC3_1.DAC2_1.sw_2.vin2 DAC4_1.DAC3_1.sw_0.vin2 0.22109f
C1357 DAC4_1.DAC3_0.DAC2_1.sw_1.vin2 DAC4_1.DAC3_0.DAC2_1.sw_2.vin1 0.19197f
C1358 DAC4_0.DAC3_0.DAC2_0.sw_2.XM6.G DAC4_0.DAC3_0.sw_0.XM8.G 0
C1359 DAC4_0.DAC3_1.DAC2_1.sw_2.vin1 li_6_1907# 0
C1360 DAC4_0.DAC3_1.sw_0.XM8.G DAC4_0.DAC3_1.DAC2_1.sw_2.XM6.G 0
C1361 DAC4_0.DAC3_1.sw_0.XM6.G DAC4_0.DAC3_1.DAC2_1.sw_2.XM8.G 0
C1362 DAC4_1.DAC3_0.DAC2_1.sw_2.XM8.G DAC4_1.sw_0.XM6.G 0
C1363 DAC4_1.DAC3_0.DAC2_1.sw_1.XM6.G DAC4_1.DAC3_0.DAC2_1.sw_0.vin1 0.00197f
C1364 DAC4_1.DAC3_0.sw_0.vin1 b2 0.18757f
C1365 DAC4_0.DAC3_1.DAC2_0.sw_2.XM8.G DAC4_0.sw_0.vin2 0.00801f
C1366 DAC4_0.DAC3_0.DAC2_0.sw_1.vin2 li_8_12747# 0.02115f
C1367 sw_0.vin2 DAC4_0.DAC3_0.DAC2_1.sw_2.XM8.G 0
C1368 DAC4_1.vrefh DAC4_0.DAC3_1.sw_0.vin2 0
C1369 DAC4_1.DAC3_1.DAC2_0.sw_1.XM8.G DAC4_1.DAC3_0.DAC2_1.sw_2.vin2 0
C1370 DAC4_0.DAC3_1.DAC2_1.sw_2.vin1 DAC4_1.vrefh 0.01454f
C1371 DAC4_1.DAC3_0.DAC2_0.sw_2.vin2 b0 0
C1372 b0 DAC4_1.DAC3_1.DAC2_1.vrefh 0.54824f
C1373 DAC4_1.DAC3_0.DAC2_1.sw_0.XM8.G avdd 0.56244f
C1374 DAC4_1.sw_0.vin1 DAC4_1.DAC3_1.DAC2_0.sw_2.vin2 0
C1375 DAC4_0.DAC3_1.DAC2_0.sw_1.vin1 DAC4_0.DAC3_1.vrefh 0.01214f
C1376 vrefl li_11371_12762# 0
C1377 DAC4_0.DAC3_1.DAC2_1.sw_2.XM6.G DAC4_0.DAC3_1.DAC2_1.sw_2.XM8.G 0.33977f
C1378 DAC4_1.DAC3_1.DAC2_0.sw_0.vin1 li_11371_9136# 0.02024f
C1379 DAC4_1.DAC3_0.DAC2_0.sw_2.XM8.G DAC4_1.DAC3_0.sw_0.XM8.G 0
C1380 DAC4_0.DAC3_1.DAC2_0.sw_2.vin2 DAC4_0.DAC3_1.DAC2_1.sw_1.XM8.G 0
C1381 li_8_10031# DAC4_0.DAC3_0.DAC2_1.sw_1.vin1 0
C1382 DAC4_0.DAC3_1.DAC2_0.sw_2.vin2 DAC4_0.DAC3_1.DAC2_0.sw_1.XM8.G 0
C1383 DAC4_1.sw_0.vin1 DAC4_1.sw_0.XM6.G 0.30094f
C1384 DAC4_0.DAC3_1.DAC2_0.sw_0.vin1 b2 0.02314f
C1385 b0 DAC4_0.DAC3_0.DAC2_0.sw_1.XM8.G 0
C1386 DAC4_0.sw_0.vin1 DAC4_0.DAC3_1.DAC2_0.sw_2.XM6.G 0
C1387 DAC4_0.DAC3_1.DAC2_0.sw_2.vin1 DAC4_0.DAC3_1.DAC2_0.sw_1.vin2 0.19198f
C1388 b1 DAC4_1.DAC3_1.vrefh 0
C1389 b1 b0 0
C1390 li_11371_12762# DAC4_1.DAC3_1.DAC2_1.sw_0.XM6.G 0
C1391 DAC4_0.DAC3_1.sw_0.XM8.G DAC4_0.sw_0.vin2 0.4592f
C1392 li_11371_11852# avdd 0.43969f
C1393 DAC4_1.sw_0.vin2 b2 0
C1394 DAC4_1.DAC3_1.DAC2_0.sw_1.XM6.G DAC4_1.DAC3_1.DAC2_0.sw_0.XM6.G 0.00169f
C1395 DAC4_1.DAC3_0.DAC2_0.sw_0.vin1 DAC4_1.DAC3_0.DAC2_0.sw_1.XM8.G 0
C1396 b0 li_8_10927# 0.01165f
C1397 DAC4_1.DAC3_1.sw_0.XM6.G DAC4_1.DAC3_1.DAC2_1.sw_2.XM8.G 0
C1398 DAC4_1.DAC3_0.DAC2_0.sw_0.vin1 avdd 0.71993f
C1399 DAC4_0.DAC3_1.DAC2_1.sw_2.vin2 DAC4_0.DAC3_1.DAC2_1.sw_0.XM8.G 0.46313f
C1400 DAC4_0.DAC3_1.DAC2_1.vrefh li_6_3713# 0.03589f
C1401 b0 DAC4_1.DAC3_0.DAC2_0.sw_2.vin1 0.00314f
C1402 DAC4_0.DAC3_0.sw_0.vin1 DAC4_0.DAC3_0.sw_0.XM8.G 0.26095f
C1403 DAC4_0.DAC3_1.DAC2_0.sw_2.vin2 DAC4_0.DAC3_1.sw_0.vin2 0
C1404 DAC4_1.DAC3_0.DAC2_1.sw_2.vin2 avdd 0.73062f
C1405 DAC4_1.sw_0.XM6.G sw_0.vin2 0.11038f
C1406 DAC4_1.DAC3_0.DAC2_0.sw_1.vin2 DAC4_1.DAC3_0.DAC2_1.vrefh 0.01211f
C1407 DAC4_0.sw_0.vin1 DAC4_0.DAC3_1.sw_0.vin1 0
C1408 DAC4_1.DAC3_0.DAC2_1.sw_1.XM6.G b2 0.00219f
C1409 b2 DAC4_1.DAC3_0.sw_0.vin2 0.15143f
C1410 DAC4_1.DAC3_0.sw_0.vin1 DAC4_1.DAC3_0.DAC2_1.sw_2.vin2 0
C1411 DAC4_0.DAC3_0.DAC2_1.sw_2.vin2 DAC4_0.DAC3_0.DAC2_1.sw_1.XM6.G 0
C1412 DAC4_0.DAC3_1.DAC2_1.sw_2.XM8.G DAC4_0.sw_0.vin2 0
C1413 DAC4_1.DAC3_0.DAC2_1.sw_2.vin1 DAC4_1.DAC3_0.DAC2_1.sw_2.XM6.G 0.30016f
C1414 DAC4_0.DAC3_0.DAC2_0.sw_1.vin2 avdd 0.58512f
C1415 DAC4_1.DAC3_0.DAC2_1.sw_2.XM8.G b2 0
C1416 DAC4_0.DAC3_1.vrefh DAC4_0.DAC3_0.DAC2_1.sw_2.vin2 0.20479f
C1417 li_6_87# DAC4_1.vrefh 0.12394f
C1418 b0 li_11371_10046# 0.01165f
C1419 DAC4_1.DAC3_0.DAC2_1.sw_1.XM6.G DAC4_1.DAC3_0.DAC2_1.sw_0.XM8.G 0
C1420 sw_0.XM6.G avdd 1.0519f
C1421 DAC4_1.DAC3_1.DAC2_1.sw_0.vin1 DAC4_1.DAC3_1.DAC2_1.sw_1.XM6.G 0.00197f
C1422 DAC4_1.DAC3_0.DAC2_0.sw_1.XM8.G DAC4_1.DAC3_0.DAC2_0.sw_0.XM6.G 0
C1423 b0 DAC4_1.DAC3_1.DAC2_0.sw_2.vin1 0
C1424 b1 DAC4_0.DAC3_0.DAC2_1.sw_0.vin1 0
C1425 DAC4_1.DAC3_0.DAC2_1.sw_2.XM8.G DAC4_1.DAC3_0.DAC2_1.sw_0.XM8.G 0
C1426 avdd DAC4_1.DAC3_0.DAC2_0.sw_0.XM6.G 1.05218f
C1427 DAC4_0.sw_0.vin1 DAC4_0.DAC3_0.sw_0.XM8.G 0.45195f
C1428 b1 DAC4_0.DAC3_1.DAC2_0.sw_2.XM6.G 0.12684f
C1429 DAC4_0.DAC3_0.DAC2_1.sw_1.XM6.G DAC4_0.DAC3_0.DAC2_1.sw_1.vin1 0.30012f
C1430 b1 DAC4_0.DAC3_1.DAC2_0.sw_0.XM8.G 0.00176f
C1431 DAC4_1.DAC3_1.vrefh DAC4_1.DAC3_1.DAC2_0.sw_1.vin1 0.01214f
C1432 DAC4_0.DAC3_0.DAC2_0.sw_2.XM6.G DAC4_0.DAC3_0.sw_0.XM6.G 0
C1433 DAC4_1.sw_0.vin1 b2 0
C1434 DAC4_0.DAC3_1.sw_0.XM6.G DAC4_0.DAC3_1.DAC2_1.sw_2.XM6.G 0
C1435 DAC4_0.sw_0.vin1 DAC4_0.DAC3_0.DAC2_1.sw_0.XM8.G 0
C1436 DAC4_1.DAC3_1.DAC2_0.sw_0.XM8.G li_11371_9136# 0
C1437 avdd b4 0.6205f
C1438 b0 DAC4_1.DAC3_1.DAC2_0.sw_1.vin1 0.35806f
C1439 vrefh avss 0.28254f
C1440 vout avss 0.98795f
C1441 vrefl avss 1.98797f
C1442 avdd avss 0.12892p
C1443 DAC4_1.DAC3_0.DAC2_0.sw_1.vin2 avss 1.60695f
C1444 DAC4_1.DAC3_0.DAC2_0.sw_1.vin1 avss 1.21325f
C1445 DAC4_1.vrefh avss 6.59971f
C1446 DAC4_0.DAC3_1.DAC2_1.sw_0.vin1 avss 1.37345f
C1447 DAC4_0.DAC3_1.DAC2_1.sw_0.XM6.G avss 1.32772f
C1448 DAC4_1.DAC3_0.DAC2_0.sw_2.vin1 avss 2.41547f
C1449 DAC4_0.DAC3_1.DAC2_1.sw_2.vin2 avss 1.88709f
C1450 DAC4_0.DAC3_1.DAC2_1.sw_2.XM6.G avss 1.32895f
C1451 DAC4_1.DAC3_0.DAC2_1.vrefh avss 1.38615f
C1452 DAC4_1.DAC3_0.DAC2_0.sw_2.vin2 avss 2.01364f
C1453 DAC4_1.DAC3_0.DAC2_0.sw_0.vin1 avss 1.51802f
C1454 DAC4_0.DAC3_1.DAC2_1.sw_1.vin2 avss 1.46058f
C1455 DAC4_0.DAC3_1.DAC2_1.sw_2.vin1 avss 1.86934f
C1456 DAC4_0.DAC3_1.DAC2_1.sw_1.vin1 avss 1.3124f
C1457 DAC4_0.DAC3_1.DAC2_1.sw_1.XM6.G avss 1.32434f
C1458 DAC4_1.DAC3_0.sw_0.vin1 avss 2.63338f
C1459 DAC4_1.DAC3_0.sw_0.XM8.G avss 0.50989f
C1460 DAC4_0.DAC3_1.sw_0.vin2 avss 4.14016f
C1461 DAC4_0.DAC3_1.sw_0.XM6.G avss 1.32593f
C1462 DAC4_1.DAC3_0.DAC2_1.sw_1.vin2 avss 1.90596f
C1463 DAC4_1.DAC3_0.DAC2_1.sw_1.vin1 avss 1.24875f
C1464 DAC4_0.DAC3_1.DAC2_1.vrefh avss 1.44944f
C1465 DAC4_0.DAC3_1.DAC2_0.sw_0.vin1 avss 1.30566f
C1466 DAC4_0.DAC3_1.DAC2_0.sw_0.XM8.G avss 0.042f
C1467 DAC4_0.DAC3_1.DAC2_0.sw_0.XM6.G avss 1.32572f
C1468 DAC4_1.DAC3_0.sw_0.vin2 avss 4.28421f
C1469 DAC4_1.DAC3_0.DAC2_1.sw_2.vin1 avss 2.68706f
C1470 DAC4_0.DAC3_1.DAC2_0.sw_2.vin2 avss 1.91719f
C1471 DAC4_0.DAC3_1.sw_0.vin1 avss 2.16927f
C1472 DAC4_0.DAC3_1.DAC2_0.sw_2.XM8.G avss 0.04204f
C1473 DAC4_0.DAC3_1.DAC2_0.sw_2.XM6.G avss 1.32831f
C1474 DAC4_1.DAC3_1.vrefh avss 2.55726f
C1475 DAC4_1.DAC3_0.DAC2_1.sw_2.vin2 avss 2.23696f
C1476 DAC4_1.DAC3_0.DAC2_1.sw_0.vin1 avss 1.77136f
C1477 DAC4_0.DAC3_1.DAC2_0.sw_1.vin2 avss 1.75899f
C1478 DAC4_0.DAC3_1.DAC2_0.sw_2.vin1 avss 1.87407f
C1479 DAC4_0.DAC3_1.DAC2_0.sw_1.vin1 avss 0.98784f
C1480 DAC4_0.DAC3_1.DAC2_0.sw_1.XM8.G avss 0.04262f
C1481 DAC4_0.DAC3_1.DAC2_0.sw_1.XM6.G avss 1.3243f
C1482 DAC4_1.sw_0.vin1 avss 3.81994f
C1483 DAC4_0.sw_0.vin2 avss 4.25223f
C1484 DAC4_0.sw_0.XM6.G avss 1.32935f
C1485 DAC4_1.DAC3_1.DAC2_0.sw_1.vin2 avss 1.64981f
C1486 DAC4_1.DAC3_1.DAC2_0.sw_1.vin1 avss 1.24571f
C1487 sw_0.vin1 avss 1.73683f
C1488 sw_0.XM6.G avss 1.33325f
C1489 sw_0.XM8.G avss 0.08427f
C1490 sw_0.vin2 avss 2.73548f
C1491 DAC4_0.DAC3_1.vrefh avss 2.70201f
C1492 DAC4_0.DAC3_0.DAC2_1.sw_0.vin1 avss 1.32522f
C1493 DAC4_0.DAC3_0.DAC2_1.sw_0.XM6.G avss 1.32564f
C1494 DAC4_1.DAC3_1.DAC2_0.sw_2.vin1 avss 2.17928f
C1495 DAC4_0.DAC3_0.DAC2_1.sw_2.vin2 avss 1.96091f
C1496 DAC4_0.DAC3_0.DAC2_1.sw_2.XM6.G avss 1.32754f
C1497 DAC4_1.DAC3_1.DAC2_1.vrefh avss 1.38615f
C1498 DAC4_1.DAC3_1.DAC2_0.sw_2.vin2 avss 2.59544f
C1499 DAC4_1.DAC3_1.DAC2_0.sw_0.vin1 avss 1.77287f
C1500 DAC4_0.DAC3_0.DAC2_1.sw_1.vin2 avss 1.80289f
C1501 DAC4_0.DAC3_0.DAC2_1.sw_2.vin1 avss 1.8599f
C1502 DAC4_0.DAC3_0.DAC2_1.sw_1.vin1 avss 0.97008f
C1503 DAC4_0.DAC3_0.DAC2_1.sw_1.XM6.G avss 1.32434f
C1504 DAC4_1.sw_0.vin2 avss 3.97157f
C1505 DAC4_1.DAC3_1.sw_0.vin1 avss 2.82208f
C1506 DAC4_0.DAC3_0.sw_0.vin2 avss 3.71691f
C1507 DAC4_0.sw_0.vin1 avss 3.3737f
C1508 DAC4_0.DAC3_0.sw_0.XM6.G avss 1.32593f
C1509 DAC4_1.DAC3_1.DAC2_1.sw_1.vin2 avss 1.9797f
C1510 DAC4_1.DAC3_1.DAC2_1.sw_1.vin1 avss 0.93562f
C1511 DAC4_0.DAC3_0.DAC2_1.vrefh avss 1.4542f
C1512 DAC4_0.DAC3_0.DAC2_0.sw_0.vin1 avss 1.33362f
C1513 DAC4_0.DAC3_0.DAC2_0.sw_0.XM6.G avss 1.32561f
C1514 DAC4_1.DAC3_1.sw_0.vin2 avss 4.48187f
C1515 DAC4_1.DAC3_1.DAC2_1.sw_2.vin1 avss 2.45434f
C1516 DAC4_0.DAC3_0.DAC2_0.sw_2.vin2 avss 2.37226f
C1517 DAC4_0.DAC3_0.sw_0.vin1 avss 2.63388f
C1518 DAC4_0.DAC3_0.DAC2_0.sw_2.XM8.G avss 0.04249f
C1519 DAC4_0.DAC3_0.DAC2_0.sw_2.XM6.G avss 1.32711f
C1520 DAC4_1.DAC3_1.DAC2_1.sw_2.vin2 avss 2.15282f
C1521 DAC4_1.DAC3_1.DAC2_1.sw_0.vin1 avss 1.04212f
C1522 DAC4_0.DAC3_0.DAC2_0.sw_1.vin2 avss 1.87534f
C1523 DAC4_0.DAC3_0.DAC2_0.sw_2.vin1 avss 1.60665f
C1524 DAC4_0.DAC3_0.DAC2_0.sw_1.vin1 avss 1.07173f
C1525 DAC4_0.DAC3_0.DAC2_0.sw_1.XM6.G avss 1.32517f
C1526 DAC4_0.DAC3_0.DAC2_0.sw_1.XM6.G.n0 avss 0.83409f
C1527 DAC4_0.DAC3_0.DAC2_0.sw_1.XM6.G.n1 avss 0.4236f
C1528 DAC4_0.DAC3_0.DAC2_0.sw_1.XM6.G.n2 avss 0.23563f
C1529 DAC4_0.DAC3_0.DAC2_0.sw_1.XM6.G.t1 avss 0.05433f
C1530 DAC4_0.DAC3_0.DAC2_0.sw_1.XM6.G.n3 avss 0.06509f
C1531 DAC4_0.DAC3_0.DAC2_0.sw_1.XM6.G.n4 avss 0.02755f
C1532 DAC4_0.DAC3_0.DAC2_0.sw_1.XM6.G.t0 avss 0.0513f
C1533 DAC4_0.DAC3_0.DAC2_0.sw_2.XM6.G.n0 avss 0.8332f
C1534 DAC4_0.DAC3_0.DAC2_0.sw_2.XM6.G.n1 avss 0.42315f
C1535 DAC4_0.DAC3_0.DAC2_0.sw_2.XM6.G.n2 avss 0.23538f
C1536 DAC4_0.DAC3_0.DAC2_0.sw_2.XM6.G.t1 avss 0.05427f
C1537 DAC4_0.DAC3_0.DAC2_0.sw_2.XM6.G.n3 avss 0.06502f
C1538 DAC4_0.DAC3_0.DAC2_0.sw_2.XM6.G.n4 avss 0.02752f
C1539 DAC4_0.DAC3_0.DAC2_0.sw_2.XM6.G.t0 avss 0.05125f
C1540 DAC4_0.DAC3_0.DAC2_0.sw_0.XM6.G.n0 avss 0.83382f
C1541 DAC4_0.DAC3_0.DAC2_0.sw_0.XM6.G.n1 avss 0.42347f
C1542 DAC4_0.DAC3_0.DAC2_0.sw_0.XM6.G.n2 avss 0.23556f
C1543 DAC4_0.DAC3_0.DAC2_0.sw_0.XM6.G.t1 avss 12.01611f
C1544 DAC4_0.DAC3_0.DAC2_0.sw_0.XM6.G.n3 avss 0.06507f
C1545 DAC4_0.DAC3_0.DAC2_0.sw_0.XM6.G.n4 avss 0.02754f
C1546 DAC4_0.DAC3_0.DAC2_0.sw_0.XM6.G.t0 avss 0.05129f
C1547 DAC4_0.DAC3_0.sw_0.XM6.G.n0 avss 0.83388f
C1548 DAC4_0.DAC3_0.sw_0.XM6.G.n1 avss 0.4235f
C1549 DAC4_0.DAC3_0.sw_0.XM6.G.n2 avss 0.23558f
C1550 DAC4_0.DAC3_0.sw_0.XM6.G.t1 avss 0.05432f
C1551 DAC4_0.DAC3_0.sw_0.XM6.G.n3 avss 0.06508f
C1552 DAC4_0.DAC3_0.sw_0.XM6.G.n4 avss 0.02754f
C1553 DAC4_0.DAC3_0.sw_0.XM6.G.t0 avss 0.05129f
C1554 DAC4_0.DAC3_0.DAC2_1.sw_1.XM6.G.n0 avss 0.83558f
C1555 DAC4_0.DAC3_0.DAC2_1.sw_1.XM6.G.n1 avss 0.42436f
C1556 DAC4_0.DAC3_0.DAC2_1.sw_1.XM6.G.n2 avss 0.23606f
C1557 DAC4_0.DAC3_0.DAC2_1.sw_1.XM6.G.t1 avss 0.05443f
C1558 DAC4_0.DAC3_0.DAC2_1.sw_1.XM6.G.n3 avss 0.06521f
C1559 DAC4_0.DAC3_0.DAC2_1.sw_1.XM6.G.n4 avss 0.0276f
C1560 DAC4_0.DAC3_0.DAC2_1.sw_1.XM6.G.t0 avss 0.05139f
C1561 DAC4_0.DAC3_0.DAC2_1.sw_2.XM6.G.n0 avss 0.8339f
C1562 DAC4_0.DAC3_0.DAC2_1.sw_2.XM6.G.n1 avss 0.42351f
C1563 DAC4_0.DAC3_0.DAC2_1.sw_2.XM6.G.n2 avss 0.23558f
C1564 DAC4_0.DAC3_0.DAC2_1.sw_2.XM6.G.t1 avss 0.05432f
C1565 DAC4_0.DAC3_0.DAC2_1.sw_2.XM6.G.n3 avss 0.06508f
C1566 DAC4_0.DAC3_0.DAC2_1.sw_2.XM6.G.n4 avss 0.02754f
C1567 DAC4_0.DAC3_0.DAC2_1.sw_2.XM6.G.t0 avss 0.05129f
C1568 DAC4_0.DAC3_0.DAC2_1.sw_0.XM6.G.n0 avss 0.83419f
C1569 DAC4_0.DAC3_0.DAC2_1.sw_0.XM6.G.n1 avss 0.42366f
C1570 DAC4_0.DAC3_0.DAC2_1.sw_0.XM6.G.n2 avss 0.23566f
C1571 DAC4_0.DAC3_0.DAC2_1.sw_0.XM6.G.t1 avss 0.05434f
C1572 DAC4_0.DAC3_0.DAC2_1.sw_0.XM6.G.n3 avss 0.0651f
C1573 DAC4_0.DAC3_0.DAC2_1.sw_0.XM6.G.n4 avss 0.02755f
C1574 DAC4_0.DAC3_0.DAC2_1.sw_0.XM6.G.t0 avss 0.05131f
C1575 DAC4_0.DAC3_1.vrefh.t1 avss 0.08596f
C1576 DAC4_0.DAC3_1.vrefh.t2 avss 0.10113f
C1577 DAC4_0.DAC3_1.vrefh.n0 avss 0.74664f
C1578 DAC4_0.DAC3_1.vrefh.t0 avss 0.06781f
C1579 sw_0.XM6.G.n0 avss 0.82561f
C1580 sw_0.XM6.G.n1 avss 0.42516f
C1581 sw_0.XM6.G.n2 avss 0.23207f
C1582 sw_0.XM6.G.t1 avss 0.41513f
C1583 sw_0.XM6.G.n3 avss 0.0337f
C1584 sw_0.XM6.G.n4 avss 0.06495f
C1585 sw_0.XM6.G.t0 avss 0.05113f
C1586 DAC4_0.sw_0.XM6.G.n0 avss 0.83463f
C1587 DAC4_0.sw_0.XM6.G.n1 avss 0.42388f
C1588 DAC4_0.sw_0.XM6.G.n2 avss 0.23579f
C1589 DAC4_0.sw_0.XM6.G.t1 avss 0.05437f
C1590 DAC4_0.sw_0.XM6.G.n3 avss 0.06514f
C1591 DAC4_0.sw_0.XM6.G.n4 avss 0.02757f
C1592 DAC4_0.sw_0.XM6.G.t0 avss 2.57334f
C1593 DAC4_0.DAC3_1.DAC2_0.sw_1.XM6.G.n0 avss 0.8356f
C1594 DAC4_0.DAC3_1.DAC2_0.sw_1.XM6.G.n1 avss 0.42437f
C1595 DAC4_0.DAC3_1.DAC2_0.sw_1.XM6.G.n2 avss 0.23606f
C1596 DAC4_0.DAC3_1.DAC2_0.sw_1.XM6.G.t1 avss 0.05443f
C1597 DAC4_0.DAC3_1.DAC2_0.sw_1.XM6.G.n3 avss 0.06521f
C1598 DAC4_0.DAC3_1.DAC2_0.sw_1.XM6.G.n4 avss 0.0276f
C1599 DAC4_0.DAC3_1.DAC2_0.sw_1.XM6.G.t0 avss 0.0514f
C1600 DAC4_1.DAC3_1.vrefh.n0 avss 0.13557f
C1601 DAC4_1.DAC3_1.vrefh.t2 avss 0.04654f
C1602 DAC4_1.DAC3_1.vrefh.t1 avss 0.11188f
C1603 DAC4_1.DAC3_1.vrefh.n1 avss 0.74507f
C1604 DAC4_1.DAC3_1.vrefh.t0 avss 0.04394f
C1605 DAC4_0.DAC3_1.DAC2_0.sw_2.XM6.G.n0 avss 0.83498f
C1606 DAC4_0.DAC3_1.DAC2_0.sw_2.XM6.G.n1 avss 0.42406f
C1607 DAC4_0.DAC3_1.DAC2_0.sw_2.XM6.G.n2 avss 0.23588f
C1608 DAC4_0.DAC3_1.DAC2_0.sw_2.XM6.G.t1 avss 0.05439f
C1609 DAC4_0.DAC3_1.DAC2_0.sw_2.XM6.G.n3 avss 0.06516f
C1610 DAC4_0.DAC3_1.DAC2_0.sw_2.XM6.G.n4 avss 0.02758f
C1611 DAC4_0.DAC3_1.DAC2_0.sw_2.XM6.G.t0 avss 0.05136f
C1612 DAC4_0.DAC3_1.DAC2_0.sw_0.XM6.G.n0 avss 0.83411f
C1613 DAC4_0.DAC3_1.DAC2_0.sw_0.XM6.G.n1 avss 0.42361f
C1614 DAC4_0.DAC3_1.DAC2_0.sw_0.XM6.G.n2 avss 0.23564f
C1615 DAC4_0.DAC3_1.DAC2_0.sw_0.XM6.G.t1 avss 0.05433f
C1616 DAC4_0.DAC3_1.DAC2_0.sw_0.XM6.G.n3 avss 0.06509f
C1617 DAC4_0.DAC3_1.DAC2_0.sw_0.XM6.G.n4 avss 0.02755f
C1618 DAC4_0.DAC3_1.DAC2_0.sw_0.XM6.G.t0 avss 0.0513f
C1619 DAC4_0.DAC3_1.sw_0.XM6.G.n0 avss 0.83389f
C1620 DAC4_0.DAC3_1.sw_0.XM6.G.n1 avss 0.4235f
C1621 DAC4_0.DAC3_1.sw_0.XM6.G.n2 avss 0.23558f
C1622 DAC4_0.DAC3_1.sw_0.XM6.G.t1 avss 0.05432f
C1623 DAC4_0.DAC3_1.sw_0.XM6.G.n3 avss 0.06508f
C1624 DAC4_0.DAC3_1.sw_0.XM6.G.n4 avss 0.02754f
C1625 DAC4_0.DAC3_1.sw_0.XM6.G.t0 avss 6.02574f
C1626 DAC4_0.DAC3_1.DAC2_1.sw_1.XM6.G.n0 avss 0.83558f
C1627 DAC4_0.DAC3_1.DAC2_1.sw_1.XM6.G.n1 avss 0.42436f
C1628 DAC4_0.DAC3_1.DAC2_1.sw_1.XM6.G.n2 avss 0.23605f
C1629 DAC4_0.DAC3_1.DAC2_1.sw_1.XM6.G.t1 avss 0.05443f
C1630 DAC4_0.DAC3_1.DAC2_1.sw_1.XM6.G.n3 avss 0.06521f
C1631 DAC4_0.DAC3_1.DAC2_1.sw_1.XM6.G.n4 avss 0.0276f
C1632 DAC4_0.DAC3_1.DAC2_1.sw_1.XM6.G.t0 avss 0.05139f
C1633 DAC4_0.DAC3_1.DAC2_1.sw_2.XM6.G.n0 avss 0.83539f
C1634 DAC4_0.DAC3_1.DAC2_1.sw_2.XM6.G.n1 avss 0.42426f
C1635 DAC4_0.DAC3_1.DAC2_1.sw_2.XM6.G.n2 avss 0.236f
C1636 DAC4_0.DAC3_1.DAC2_1.sw_2.XM6.G.t1 avss 8.27982f
C1637 DAC4_0.DAC3_1.DAC2_1.sw_2.XM6.G.n3 avss 0.06519f
C1638 DAC4_0.DAC3_1.DAC2_1.sw_2.XM6.G.n4 avss 0.02759f
C1639 DAC4_0.DAC3_1.DAC2_1.sw_2.XM6.G.t0 avss 0.05138f
C1640 DAC4_0.DAC3_1.DAC2_1.sw_0.XM6.G.n0 avss 0.83472f
C1641 DAC4_0.DAC3_1.DAC2_1.sw_0.XM6.G.n1 avss 0.42392f
C1642 DAC4_0.DAC3_1.DAC2_1.sw_0.XM6.G.n2 avss 0.23581f
C1643 DAC4_0.DAC3_1.DAC2_1.sw_0.XM6.G.t1 avss 0.05437f
C1644 DAC4_0.DAC3_1.DAC2_1.sw_0.XM6.G.n3 avss 0.06514f
C1645 DAC4_0.DAC3_1.DAC2_1.sw_0.XM6.G.n4 avss 0.02757f
C1646 DAC4_0.DAC3_1.DAC2_1.sw_0.XM6.G.t0 avss 0.05134f
C1647 avss.t45 avss 0.50947f
C1648 avss.t56 avss 0.042f
C1649 avss.t63 avss 0.04207f
C1650 avss.t59 avss 0.04198f
C1651 avss.t1 avss 0.04199f
C1652 avss.t76 avss 0.50989f
C1653 avss.t11 avss 0.04195f
C1654 avss.t169 avss 0.04203f
C1655 avss.t138 avss 0.04206f
C1656 avss.t134 avss 0.04199f
C1657 avss.t161 avss 5.97445f
C1658 avss.t113 avss 0.04204f
C1659 avss.t28 avss 0.04198f
C1660 avss.t152 avss 0.04187f
C1661 avss.t67 avss 0.51064f
C1662 avss.t19 avss 0.50876f
C1663 avss.t47 avss 0.04202f
C1664 avss.t182 avss 2.522f
C1665 avss.t150 avss 0.042f
C1666 avss.t145 avss 0.04199f
C1667 avss.t7 avss 0.04207f
C1668 avss.t148 avss 0.04207f
C1669 avss.t173 avss 0.51144f
C1670 avdd.n0 avss 2.16694f
C1671 avdd.n1 avss 2.213f
C1672 avdd.n2 avss 1.57374f
C1673 avdd.n3 avss 2.15977f
C1674 avdd.n4 avss 2.16694f
C1675 avdd.n5 avss 1.57374f
C1676 avdd.n6 avss 2.15977f
C1677 avdd.n7 avss 2.21296f
C1678 avdd.n8 avss 0.07828f
C1679 avdd.n9 avss 1.51922f
C1680 avdd.n10 avss 0.07734f
C1681 avdd.t150 avss 0.1053f
C1682 avdd.n11 avss 0.5004f
C1683 avdd.n12 avss 0.50022f
C1684 avdd.n13 avss 0.07734f
C1685 avdd.n14 avss 0.07734f
C1686 avdd.n15 avss 0.07734f
C1687 avdd.n16 avss 0.07734f
C1688 avdd.n17 avss 0.07734f
C1689 avdd.n18 avss 0.05027f
C1690 avdd.n19 avss 0.5004f
C1691 avdd.n20 avss 0.50022f
C1692 avdd.n21 avss 0.07734f
C1693 avdd.n22 avss 0.19282f
C1694 avdd.n23 avss 0.07734f
C1695 avdd.n24 avss 0.50022f
C1696 avdd.n25 avss 0.07734f
C1697 avdd.n26 avss 0.07734f
C1698 avdd.n27 avss 0.50022f
C1699 avdd.n28 avss 0.07734f
C1700 avdd.n29 avss 0.07734f
C1701 avdd.n30 avss 0.07734f
C1702 avdd.n31 avss 0.07734f
C1703 avdd.n32 avss 0.07734f
C1704 avdd.n33 avss 0.07734f
C1705 avdd.n34 avss 0.07734f
C1706 avdd.n35 avss 0.07734f
C1707 avdd.n36 avss 0.07734f
C1708 avdd.n37 avss 0.07734f
C1709 avdd.n38 avss 0.50022f
C1710 avdd.n39 avss 0.07734f
C1711 avdd.n40 avss 0.07734f
C1712 avdd.n41 avss 0.07734f
C1713 avdd.n42 avss 0.07734f
C1714 avdd.n43 avss 1.28257f
C1715 avdd.n44 avss 0.07734f
C1716 avdd.n45 avss 1.80105f
C1717 avdd.n46 avss 1.80105f
C1718 avdd.n47 avss 0.93655f
C1719 avdd.n48 avss 1.28257f
C1720 avdd.n49 avss 0.19245f
C1721 avdd.n50 avss 0.01475f
C1722 avdd.n51 avss 0.19245f
C1723 avdd.n52 avss 0.01475f
C1724 avdd.n53 avss 0.19245f
C1725 avdd.n54 avss 0.01475f
C1726 avdd.n55 avss 0.06826f
C1727 avdd.n56 avss 0.07828f
C1728 avdd.n57 avss 0.01475f
C1729 avdd.n58 avss 0.19245f
C1730 avdd.n59 avss 0.19245f
C1731 avdd.n60 avss 0.06826f
C1732 avdd.n61 avss 0.07828f
C1733 avdd.n62 avss 0.19245f
C1734 avdd.n63 avss 0.0654f
C1735 avdd.n64 avss 0.07828f
C1736 avdd.n65 avss 0.19245f
C1737 avdd.n66 avss 0.0654f
C1738 avdd.n67 avss 0.5004f
C1739 avdd.n68 avss 0.07828f
C1740 avdd.n69 avss 0.19245f
C1741 avdd.n70 avss 0.19245f
C1742 avdd.n71 avss 0.07828f
C1743 avdd.n72 avss 1.12151f
C1744 avdd.n73 avss 0.16963f
C1745 avdd.n74 avss 0.19245f
C1746 avdd.n75 avss 0.19245f
C1747 avdd.n76 avss 0.07828f
C1748 avdd.n77 avss 0.19245f
C1749 avdd.n78 avss 0.19245f
C1750 avdd.n79 avss 0.0654f
C1751 avdd.n80 avss 0.5004f
C1752 avdd.n81 avss 0.01475f
C1753 avdd.n82 avss 0.16981f
C1754 avdd.n83 avss 0.01475f
C1755 avdd.n84 avss 0.19245f
C1756 avdd.n85 avss 0.01475f
C1757 avdd.n86 avss 0.06826f
C1758 avdd.n87 avss 0.07828f
C1759 avdd.n88 avss 0.01475f
C1760 avdd.n89 avss 0.19245f
C1761 avdd.n90 avss 0.07828f
C1762 avdd.n91 avss 0.09791f
C1763 avdd.n92 avss 0.04448f
C1764 avdd.n93 avss 0.46168f
C1765 avdd.n94 avss 1.12136f
C1766 avdd.t142 avss 0.27524f
C1767 avdd.n95 avss 0.16038f
C1768 avdd.n96 avss 0.26344f
C1769 avdd.n97 avss 0.16038f
C1770 avdd.n98 avss 0.26344f
C1771 avdd.n99 avss 0.26344f
C1772 avdd.n100 avss 0.16038f
C1773 avdd.n101 avss 0.26344f
C1774 avdd.n102 avss 0.02746f
C1775 avdd.n103 avss 0.65633f
C1776 avdd.n104 avss 0.18607f
C1777 avdd.n105 avss 0.26344f
C1778 avdd.n106 avss 0.26344f
C1779 avdd.n107 avss 0.26344f
C1780 avdd.n108 avss 0.26344f
C1781 avdd.n109 avss 0.26344f
C1782 avdd.n110 avss 0.26344f
C1783 avdd.n111 avss 0.26344f
C1784 avdd.n112 avss 0.26344f
C1785 avdd.n113 avss 0.26344f
C1786 avdd.n114 avss 0.26344f
C1787 avdd.n115 avss 0.26344f
C1788 avdd.n116 avss 0.26344f
C1789 avdd.n117 avss 0.26344f
C1790 avdd.n118 avss 0.26344f
C1791 avdd.n119 avss 0.16038f
C1792 avdd.t84 avss 12.23704f
C1793 avdd.n120 avss 0.16038f
C1794 avdd.t80 avss 0.27524f
C1795 avdd.n121 avss 0.0676f
C1796 avdd.t38 avss 0.10526f
C1797 avdd.n122 avss 0.23351f
C1798 avdd.n123 avss 0.01909f
C1799 avdd.t118 avss 0.06114f
C1800 avdd.n124 avss 0.16038f
C1801 avdd.n125 avss 0.18532f
C1802 avdd.n126 avss 0.01475f
C1803 avdd.n127 avss 0.01909f
C1804 avdd.n128 avss 0.01909f
C1805 avdd.n129 avss 0.01909f
C1806 avdd.n130 avss 0.18532f
C1807 avdd.n131 avss 0.01475f
C1808 avdd.n132 avss 0.01909f
C1809 avdd.n133 avss 0.01475f
C1810 avdd.n134 avss 0.07695f
C1811 avdd.n135 avss 0.06826f
C1812 avdd.n136 avss 0.18532f
C1813 avdd.n137 avss 0.01909f
C1814 avdd.n138 avss 0.01426f
C1815 avdd.n139 avss 0.15077f
C1816 avdd.n140 avss 0.01909f
C1817 avdd.t128 avss 0.20733f
C1818 avdd.n141 avss 0.01909f
C1819 avdd.n142 avss 0.01171f
C1820 avdd.n143 avss 0.18532f
C1821 avdd.n144 avss 0.01171f
C1822 avdd.n145 avss 0.01909f
C1823 avdd.n146 avss 0.01475f
C1824 avdd.n147 avss 0.01909f
C1825 avdd.n148 avss 0.18532f
C1826 avdd.n149 avss 0.01475f
C1827 avdd.n150 avss 0.01909f
C1828 avdd.n151 avss 0.01909f
C1829 avdd.n152 avss 0.01909f
C1830 avdd.n153 avss 0.01475f
C1831 avdd.n154 avss 0.16038f
C1832 avdd.n155 avss 0.15154f
C1833 avdd.n156 avss 0.01979f
C1834 avdd.t141 avss 0.20733f
C1835 avdd.n158 avss 0.01979f
C1836 avdd.n159 avss 0.02698f
C1837 avdd.n160 avss 0.01764f
C1838 avdd.n161 avss 0.01171f
C1839 avdd.n162 avss 0.01171f
C1840 avdd.t149 avss 0.18532f
C1841 avdd.n163 avss 0.01171f
C1842 avdd.n164 avss 0.0676f
C1843 avdd.n165 avss 0.07695f
C1844 avdd.n166 avss 0.06826f
C1845 avdd.n167 avss 0.01171f
C1846 avdd.t178 avss 0.18532f
C1847 avdd.n168 avss 0.18532f
C1848 avdd.n169 avss 0.01475f
C1849 avdd.n170 avss 0.01475f
C1850 avdd.n171 avss 0.01909f
C1851 avdd.n172 avss 0.02694f
C1852 avdd.n173 avss 0.01979f
C1853 avdd.n174 avss 0.16038f
C1854 avdd.n176 avss 0.01979f
C1855 avdd.n177 avss 0.08741f
C1856 avdd.n178 avss 0.47411f
C1857 avdd.n179 avss 0.55558f
C1858 avdd.n180 avss 0.163f
C1859 avdd.n181 avss 0.01979f
C1860 avdd.t1 avss 0.20733f
C1861 avdd.n183 avss 0.01979f
C1862 avdd.n184 avss 0.14919f
C1863 avdd.n185 avss 0.01475f
C1864 avdd.n186 avss 0.01475f
C1865 avdd.n187 avss 0.01909f
C1866 avdd.n188 avss 0.01171f
C1867 avdd.n189 avss 0.01171f
C1868 avdd.t156 avss 0.18532f
C1869 avdd.n190 avss 0.01171f
C1870 avdd.n191 avss 0.01909f
C1871 avdd.n192 avss 0.01171f
C1872 avdd.t37 avss 0.18532f
C1873 avdd.n193 avss 0.01171f
C1874 avdd.n194 avss 0.01171f
C1875 avdd.n195 avss 0.01764f
C1876 avdd.n196 avss 0.02205f
C1877 avdd.n197 avss 0.01979f
C1878 avdd.t117 avss 0.20733f
C1879 avdd.n199 avss 0.01979f
C1880 avdd.n200 avss 0.13706f
C1881 avdd.n201 avss 0.0676f
C1882 avdd.t132 avss 0.10529f
C1883 avdd.n202 avss 0.01909f
C1884 avdd.n203 avss 0.18532f
C1885 avdd.n204 avss 0.01475f
C1886 avdd.n205 avss 0.01909f
C1887 avdd.n206 avss 0.01909f
C1888 avdd.n207 avss 0.01909f
C1889 avdd.n208 avss 0.18532f
C1890 avdd.n209 avss 0.01475f
C1891 avdd.n210 avss 0.01909f
C1892 avdd.n211 avss 0.01475f
C1893 avdd.n212 avss 0.07695f
C1894 avdd.n213 avss 0.06826f
C1895 avdd.n214 avss 0.18532f
C1896 avdd.n215 avss 0.01909f
C1897 avdd.n216 avss 0.01475f
C1898 avdd.n217 avss 0.22684f
C1899 avdd.n218 avss 0.16038f
C1900 avdd.n219 avss 0.15139f
C1901 avdd.n220 avss 0.01979f
C1902 avdd.t28 avss 0.20733f
C1903 avdd.n222 avss 0.01979f
C1904 avdd.n223 avss 0.02694f
C1905 avdd.n224 avss 0.01909f
C1906 avdd.n225 avss 0.01171f
C1907 avdd.n226 avss 0.01171f
C1908 avdd.t52 avss 0.18532f
C1909 avdd.n227 avss 0.01171f
C1910 avdd.n228 avss 0.01909f
C1911 avdd.n229 avss 0.01171f
C1912 avdd.t131 avss 0.18532f
C1913 avdd.n230 avss 0.01171f
C1914 avdd.n231 avss 0.01171f
C1915 avdd.n232 avss 0.01764f
C1916 avdd.n233 avss 0.02698f
C1917 avdd.n234 avss 0.01979f
C1918 avdd.t83 avss 0.20733f
C1919 avdd.n236 avss 0.01979f
C1920 avdd.n237 avss 0.15154f
C1921 avdd.n238 avss 0.0676f
C1922 avdd.t48 avss 0.05504f
C1923 avdd.n239 avss 0.05027f
C1924 avdd.t98 avss 0.01181f
C1925 avdd.n240 avss 0.01909f
C1926 avdd.n241 avss 0.18532f
C1927 avdd.n242 avss 0.01475f
C1928 avdd.n243 avss 0.01909f
C1929 avdd.n244 avss 0.01909f
C1930 avdd.n245 avss 0.01909f
C1931 avdd.n246 avss 0.18532f
C1932 avdd.n247 avss 0.01475f
C1933 avdd.n248 avss 0.01909f
C1934 avdd.n249 avss 0.01475f
C1935 avdd.n250 avss 0.07695f
C1936 avdd.n251 avss 0.06826f
C1937 avdd.n252 avss 0.18532f
C1938 avdd.n253 avss 0.01909f
C1939 avdd.n254 avss 0.01475f
C1940 avdd.n255 avss 0.22684f
C1941 avdd.n256 avss 0.16038f
C1942 avdd.n257 avss 0.15139f
C1943 avdd.n258 avss 0.01979f
C1944 avdd.t107 avss 0.20733f
C1945 avdd.n260 avss 0.01979f
C1946 avdd.n261 avss 0.02694f
C1947 avdd.n262 avss 0.01909f
C1948 avdd.n263 avss 0.01171f
C1949 avdd.n264 avss 0.01171f
C1950 avdd.t165 avss 0.18532f
C1951 avdd.n265 avss 0.01171f
C1952 avdd.n266 avss 0.01909f
C1953 avdd.n267 avss 0.01171f
C1954 avdd.t47 avss 0.18532f
C1955 avdd.n268 avss 0.01171f
C1956 avdd.n269 avss 0.01171f
C1957 avdd.n270 avss 0.01764f
C1958 avdd.n271 avss 0.02698f
C1959 avdd.n272 avss 0.01979f
C1960 avdd.t97 avss 0.20733f
C1961 avdd.n274 avss 0.01979f
C1962 avdd.n275 avss 0.15154f
C1963 avdd.n276 avss 0.0676f
C1964 avdd.t158 avss 0.05507f
C1965 avdd.n277 avss 0.05027f
C1966 avdd.t104 avss 0.01181f
C1967 avdd.n278 avss 0.01909f
C1968 avdd.n279 avss 0.18532f
C1969 avdd.n280 avss 0.01475f
C1970 avdd.n281 avss 0.01909f
C1971 avdd.n282 avss 0.01909f
C1972 avdd.n283 avss 0.01909f
C1973 avdd.n284 avss 0.18532f
C1974 avdd.n285 avss 0.01475f
C1975 avdd.n286 avss 0.01909f
C1976 avdd.n287 avss 0.01475f
C1977 avdd.n288 avss 0.07695f
C1978 avdd.n289 avss 0.06826f
C1979 avdd.n290 avss 0.18532f
C1980 avdd.n291 avss 0.01909f
C1981 avdd.n292 avss 0.01475f
C1982 avdd.n293 avss 0.22684f
C1983 avdd.n294 avss 0.16038f
C1984 avdd.n295 avss 0.15139f
C1985 avdd.n296 avss 0.01979f
C1986 avdd.t163 avss 0.20733f
C1987 avdd.n298 avss 0.01979f
C1988 avdd.n299 avss 0.02694f
C1989 avdd.n300 avss 0.01909f
C1990 avdd.n301 avss 0.01171f
C1991 avdd.n302 avss 0.01171f
C1992 avdd.t58 avss 0.18532f
C1993 avdd.n303 avss 0.01171f
C1994 avdd.n304 avss 0.01909f
C1995 avdd.n305 avss 0.01171f
C1996 avdd.t157 avss 0.18532f
C1997 avdd.n306 avss 0.01171f
C1998 avdd.n307 avss 0.01171f
C1999 avdd.n308 avss 0.01764f
C2000 avdd.n309 avss 0.02698f
C2001 avdd.n310 avss 0.01979f
C2002 avdd.t103 avss 0.20733f
C2003 avdd.n312 avss 0.01979f
C2004 avdd.n313 avss 0.15154f
C2005 avdd.n314 avss 0.94908f
C2006 avdd.n315 avss 0.0676f
C2007 avdd.t110 avss 0.05511f
C2008 avdd.n316 avss 0.05027f
C2009 avdd.n317 avss 0.23461f
C2010 avdd.n318 avss 0.01909f
C2011 avdd.t122 avss 8.23781f
C2012 avdd.n319 avss 0.04874f
C2013 avdd.n320 avss 0.16038f
C2014 avdd.n321 avss 0.18532f
C2015 avdd.n322 avss 0.01475f
C2016 avdd.n323 avss 0.01909f
C2017 avdd.n324 avss 0.01909f
C2018 avdd.n325 avss 0.01909f
C2019 avdd.n326 avss 0.18532f
C2020 avdd.n327 avss 0.01475f
C2021 avdd.n328 avss 0.01909f
C2022 avdd.n329 avss 0.01475f
C2023 avdd.n330 avss 0.07695f
C2024 avdd.n331 avss 0.06826f
C2025 avdd.n332 avss 0.18532f
C2026 avdd.n333 avss 0.01909f
C2027 avdd.n334 avss 0.01475f
C2028 avdd.n335 avss 0.22961f
C2029 avdd.n336 avss 0.16038f
C2030 avdd.n337 avss 0.15139f
C2031 avdd.n338 avss 0.01979f
C2032 avdd.t171 avss 0.20733f
C2033 avdd.n340 avss 0.01979f
C2034 avdd.n341 avss 0.02416f
C2035 avdd.n342 avss 0.01909f
C2036 avdd.n343 avss 0.01171f
C2037 avdd.n344 avss 0.01171f
C2038 avdd.t177 avss 0.18532f
C2039 avdd.n345 avss 0.01171f
C2040 avdd.n346 avss 0.01909f
C2041 avdd.n347 avss 0.01171f
C2042 avdd.t109 avss 0.18532f
C2043 avdd.n348 avss 0.01171f
C2044 avdd.n349 avss 0.01171f
C2045 avdd.n350 avss 0.01764f
C2046 avdd.n351 avss 0.02096f
C2047 avdd.n352 avss 0.01979f
C2048 avdd.t121 avss 0.20733f
C2049 avdd.n354 avss 0.01979f
C2050 avdd.n355 avss 0.13706f
C2051 avdd.n356 avss 0.93655f
C2052 avdd.n357 avss 0.0676f
C2053 avdd.t152 avss 0.05512f
C2054 avdd.n358 avss 0.05027f
C2055 avdd.n359 avss 0.23461f
C2056 avdd.n360 avss 0.01909f
C2057 avdd.t74 avss 0.01241f
C2058 avdd.n361 avss 0.04874f
C2059 avdd.n362 avss 0.16038f
C2060 avdd.n363 avss 0.18532f
C2061 avdd.n364 avss 0.01475f
C2062 avdd.n365 avss 0.01909f
C2063 avdd.n366 avss 0.01909f
C2064 avdd.n367 avss 0.01909f
C2065 avdd.n368 avss 0.18532f
C2066 avdd.n369 avss 0.01475f
C2067 avdd.n370 avss 0.01909f
C2068 avdd.n371 avss 0.01475f
C2069 avdd.n372 avss 0.07695f
C2070 avdd.n373 avss 0.18532f
C2071 avdd.n374 avss 0.01909f
C2072 avdd.n375 avss 0.01475f
C2073 avdd.n376 avss 0.22961f
C2074 avdd.n377 avss 0.16038f
C2075 avdd.n378 avss 0.15139f
C2076 avdd.n379 avss 0.01979f
C2077 avdd.t29 avss 0.20733f
C2078 avdd.n381 avss 0.01979f
C2079 avdd.n382 avss 0.02416f
C2080 avdd.n383 avss 0.01909f
C2081 avdd.n384 avss 0.01171f
C2082 avdd.n385 avss 0.01171f
C2083 avdd.t0 avss 0.18532f
C2084 avdd.n386 avss 0.01171f
C2085 avdd.n387 avss 0.01909f
C2086 avdd.n388 avss 0.01171f
C2087 avdd.t151 avss 0.18532f
C2088 avdd.n389 avss 0.01171f
C2089 avdd.n390 avss 0.01171f
C2090 avdd.n391 avss 0.01764f
C2091 avdd.n392 avss 0.02096f
C2092 avdd.n393 avss 0.01979f
C2093 avdd.t73 avss 0.20733f
C2094 avdd.n395 avss 0.01979f
C2095 avdd.n396 avss 0.13706f
C2096 avdd.n397 avss 0.0676f
C2097 avdd.t106 avss 0.05509f
C2098 avdd.n398 avss 0.05027f
C2099 avdd.n399 avss 0.23351f
C2100 avdd.n400 avss 0.01909f
C2101 avdd.t116 avss 0.01241f
C2102 avdd.n401 avss 0.04874f
C2103 avdd.n402 avss 0.16038f
C2104 avdd.n403 avss 0.18532f
C2105 avdd.n404 avss 0.01475f
C2106 avdd.n405 avss 0.01909f
C2107 avdd.n406 avss 0.01909f
C2108 avdd.n407 avss 0.01909f
C2109 avdd.n408 avss 0.18532f
C2110 avdd.n409 avss 0.01475f
C2111 avdd.n410 avss 0.01909f
C2112 avdd.n411 avss 0.01475f
C2113 avdd.n412 avss 0.07695f
C2114 avdd.n413 avss 0.06826f
C2115 avdd.n414 avss 0.18532f
C2116 avdd.n415 avss 0.01909f
C2117 avdd.n416 avss 0.01426f
C2118 avdd.n417 avss 0.15077f
C2119 avdd.n418 avss 0.01909f
C2120 avdd.t6 avss 0.20733f
C2121 avdd.n419 avss 0.01909f
C2122 avdd.n420 avss 0.01171f
C2123 avdd.n421 avss 0.18532f
C2124 avdd.n422 avss 0.01171f
C2125 avdd.n423 avss 0.01909f
C2126 avdd.n424 avss 0.01475f
C2127 avdd.n425 avss 0.01909f
C2128 avdd.n426 avss 0.18532f
C2129 avdd.n427 avss 0.01475f
C2130 avdd.n428 avss 0.01909f
C2131 avdd.n429 avss 0.01909f
C2132 avdd.n430 avss 0.01909f
C2133 avdd.t10 avss 0.05503f
C2134 avdd.n431 avss 0.01475f
C2135 avdd.n432 avss 0.16038f
C2136 avdd.t144 avss 0.01181f
C2137 avdd.n433 avss 0.15154f
C2138 avdd.n434 avss 0.01979f
C2139 avdd.t143 avss 0.20733f
C2140 avdd.n436 avss 0.01979f
C2141 avdd.n437 avss 0.02698f
C2142 avdd.n438 avss 0.01764f
C2143 avdd.n439 avss 0.01171f
C2144 avdd.n440 avss 0.01171f
C2145 avdd.t9 avss 0.18532f
C2146 avdd.n441 avss 0.01171f
C2147 avdd.n442 avss 0.0676f
C2148 avdd.n443 avss 0.07695f
C2149 avdd.n444 avss 0.06826f
C2150 avdd.n445 avss 0.01171f
C2151 avdd.t164 avss 0.18532f
C2152 avdd.n446 avss 0.18532f
C2153 avdd.n447 avss 0.01475f
C2154 avdd.n448 avss 0.01475f
C2155 avdd.n449 avss 0.01909f
C2156 avdd.n450 avss 0.02694f
C2157 avdd.n451 avss 0.01979f
C2158 avdd.n452 avss 0.16038f
C2159 avdd.n454 avss 0.01979f
C2160 avdd.n455 avss 0.08741f
C2161 avdd.n456 avss 0.47411f
C2162 avdd.n457 avss 0.55558f
C2163 avdd.n458 avss 0.163f
C2164 avdd.n459 avss 0.01979f
C2165 avdd.t31 avss 0.20733f
C2166 avdd.n461 avss 0.01979f
C2167 avdd.n462 avss 0.14919f
C2168 avdd.n463 avss 0.01475f
C2169 avdd.n464 avss 0.01475f
C2170 avdd.n465 avss 0.01909f
C2171 avdd.n466 avss 0.01171f
C2172 avdd.n467 avss 0.01171f
C2173 avdd.t127 avss 0.18532f
C2174 avdd.n468 avss 0.01171f
C2175 avdd.n469 avss 0.01909f
C2176 avdd.n470 avss 0.01171f
C2177 avdd.t105 avss 0.18532f
C2178 avdd.n471 avss 0.01171f
C2179 avdd.n472 avss 0.01171f
C2180 avdd.n473 avss 0.01764f
C2181 avdd.n474 avss 0.02205f
C2182 avdd.n475 avss 0.01979f
C2183 avdd.t115 avss 0.20733f
C2184 avdd.n477 avss 0.01979f
C2185 avdd.n478 avss 0.13706f
C2186 avdd.n479 avss 0.93655f
C2187 avdd.n480 avss 0.0676f
C2188 avdd.t137 avss 0.05512f
C2189 avdd.n481 avss 0.05027f
C2190 avdd.t94 avss 0.01181f
C2191 avdd.n482 avss 0.01909f
C2192 avdd.n483 avss 0.18532f
C2193 avdd.n484 avss 0.01475f
C2194 avdd.n485 avss 0.01909f
C2195 avdd.n486 avss 0.01909f
C2196 avdd.n487 avss 0.01909f
C2197 avdd.n488 avss 0.18532f
C2198 avdd.n489 avss 0.01475f
C2199 avdd.n490 avss 0.01909f
C2200 avdd.n491 avss 0.01475f
C2201 avdd.n492 avss 0.07695f
C2202 avdd.n493 avss 0.18532f
C2203 avdd.n494 avss 0.01909f
C2204 avdd.n495 avss 0.02694f
C2205 avdd.t180 avss 0.01241f
C2206 avdd.n496 avss 0.11333f
C2207 avdd.n497 avss 0.09f
C2208 avdd.n498 avss 0.01909f
C2209 avdd.n499 avss 0.16038f
C2210 avdd.n500 avss 0.18532f
C2211 avdd.n501 avss 0.01171f
C2212 avdd.t8 avss 0.05507f
C2213 avdd.n502 avss 0.01475f
C2214 avdd.n503 avss 0.01909f
C2215 avdd.n504 avss 0.01909f
C2216 avdd.n505 avss 0.01909f
C2217 avdd.n506 avss 0.18532f
C2218 avdd.n507 avss 0.18532f
C2219 avdd.n508 avss 0.01909f
C2220 avdd.n509 avss 0.01475f
C2221 avdd.n510 avss 0.01909f
C2222 avdd.n511 avss 0.01475f
C2223 avdd.n512 avss 0.01475f
C2224 avdd.n513 avss 0.22961f
C2225 avdd.n514 avss 0.16038f
C2226 avdd.n515 avss 0.02416f
C2227 avdd.n516 avss 0.01979f
C2228 avdd.t15 avss 0.20733f
C2229 avdd.n518 avss 0.01979f
C2230 avdd.n519 avss 0.15139f
C2231 avdd.n520 avss 0.0676f
C2232 avdd.t57 avss 0.0549f
C2233 avdd.n521 avss 0.0509f
C2234 avdd.n522 avss 0.15354f
C2235 avdd.n523 avss 0.01909f
C2236 avdd.n524 avss 0.16038f
C2237 avdd.n525 avss 0.18532f
C2238 avdd.n526 avss 0.01909f
C2239 avdd.n527 avss 0.01475f
C2240 avdd.n528 avss 0.01475f
C2241 avdd.n529 avss 0.01909f
C2242 avdd.n530 avss 0.01909f
C2243 avdd.n531 avss 0.18532f
C2244 avdd.n532 avss 0.01909f
C2245 avdd.n533 avss 0.01475f
C2246 avdd.n534 avss 0.01475f
C2247 avdd.n535 avss 0.07695f
C2248 avdd.n536 avss 0.01909f
C2249 avdd.n537 avss 0.18532f
C2250 avdd.n538 avss 0.01909f
C2251 avdd.n539 avss 0.01475f
C2252 avdd.t169 avss 0.0125f
C2253 avdd.n540 avss 0.05027f
C2254 avdd.n541 avss 0.02694f
C2255 avdd.n542 avss 0.01979f
C2256 avdd.n543 avss 0.01979f
C2257 avdd.t16 avss 0.18532f
C2258 avdd.n544 avss 0.01909f
C2259 avdd.n545 avss 0.01909f
C2260 avdd.n546 avss 0.01909f
C2261 avdd.n547 avss 0.06826f
C2262 avdd.n548 avss 0.07695f
C2263 avdd.n549 avss 0.01909f
C2264 avdd.n550 avss 0.01909f
C2265 avdd.n551 avss 0.18532f
C2266 avdd.n552 avss 0.18532f
C2267 avdd.n553 avss 0.01909f
C2268 avdd.n554 avss 0.01909f
C2269 avdd.n555 avss 0.01475f
C2270 avdd.t14 avss 0.0125f
C2271 avdd.n556 avss 0.05027f
C2272 avdd.t75 avss 0.20733f
C2273 avdd.t76 avss 0.01181f
C2274 avdd.n557 avss 0.15154f
C2275 avdd.n558 avss 0.01979f
C2276 avdd.n559 avss 0.16038f
C2277 avdd.n561 avss 0.01979f
C2278 avdd.n562 avss 0.02698f
C2279 avdd.n563 avss 0.01764f
C2280 avdd.n564 avss 0.01475f
C2281 avdd.n565 avss 0.01475f
C2282 avdd.n566 avss 0.01909f
C2283 avdd.n567 avss 0.01909f
C2284 avdd.n568 avss 0.18532f
C2285 avdd.n569 avss 0.01475f
C2286 avdd.n570 avss 0.16038f
C2287 avdd.n571 avss 0.01475f
C2288 avdd.n572 avss 0.1614f
C2289 avdd.n573 avss 0.21683f
C2290 avdd.n574 avss 0.02694f
C2291 avdd.n575 avss 0.01979f
C2292 avdd.t11 avss 0.20733f
C2293 avdd.n577 avss 0.01979f
C2294 avdd.n578 avss 0.01909f
C2295 avdd.n579 avss 0.06826f
C2296 avdd.n580 avss 0.01171f
C2297 avdd.t12 avss 0.18532f
C2298 avdd.n581 avss 0.01171f
C2299 avdd.n582 avss 0.01171f
C2300 avdd.n583 avss 0.01909f
C2301 avdd.n584 avss 0.01171f
C2302 avdd.n585 avss 0.01171f
C2303 avdd.t13 avss 0.18532f
C2304 avdd.n586 avss 0.01171f
C2305 avdd.n587 avss 0.0676f
C2306 avdd.n588 avss 0.07695f
C2307 avdd.n589 avss 0.01909f
C2308 avdd.n590 avss 0.01909f
C2309 avdd.n591 avss 0.18532f
C2310 avdd.n592 avss 0.18532f
C2311 avdd.n593 avss 0.01909f
C2312 avdd.n594 avss 0.01909f
C2313 avdd.n595 avss 0.01475f
C2314 avdd.t61 avss 0.0125f
C2315 avdd.n596 avss 0.05027f
C2316 avdd.t81 avss 0.20733f
C2317 avdd.t82 avss 0.01181f
C2318 avdd.n597 avss 0.15154f
C2319 avdd.n598 avss 0.01979f
C2320 avdd.n599 avss 0.16038f
C2321 avdd.n601 avss 0.01979f
C2322 avdd.n602 avss 0.02698f
C2323 avdd.n603 avss 0.01764f
C2324 avdd.n604 avss 0.01475f
C2325 avdd.n605 avss 0.01475f
C2326 avdd.n606 avss 0.01909f
C2327 avdd.n607 avss 0.01909f
C2328 avdd.n608 avss 0.18532f
C2329 avdd.n609 avss 0.01475f
C2330 avdd.n610 avss 0.16038f
C2331 avdd.n611 avss 0.01475f
C2332 avdd.n612 avss 0.1614f
C2333 avdd.n613 avss 0.21683f
C2334 avdd.n614 avss 0.02694f
C2335 avdd.n615 avss 0.01979f
C2336 avdd.t138 avss 0.20733f
C2337 avdd.n617 avss 0.01979f
C2338 avdd.n618 avss 0.01909f
C2339 avdd.n619 avss 0.06826f
C2340 avdd.n620 avss 0.01171f
C2341 avdd.t59 avss 0.18532f
C2342 avdd.n621 avss 0.01171f
C2343 avdd.n622 avss 0.01171f
C2344 avdd.n623 avss 0.01909f
C2345 avdd.n624 avss 0.01171f
C2346 avdd.n625 avss 0.01171f
C2347 avdd.t60 avss 0.18532f
C2348 avdd.n626 avss 0.01171f
C2349 avdd.n627 avss 0.0676f
C2350 avdd.n628 avss 0.94908f
C2351 avdd.n629 avss 0.07695f
C2352 avdd.n630 avss 0.01909f
C2353 avdd.n631 avss 0.01909f
C2354 avdd.n632 avss 0.18532f
C2355 avdd.n633 avss 0.18532f
C2356 avdd.n634 avss 0.01909f
C2357 avdd.n635 avss 0.01909f
C2358 avdd.n636 avss 0.01475f
C2359 avdd.t4 avss 0.0125f
C2360 avdd.n637 avss 0.05027f
C2361 avdd.t111 avss 0.20733f
C2362 avdd.t112 avss 0.01181f
C2363 avdd.n638 avss 0.15154f
C2364 avdd.n639 avss 0.01979f
C2365 avdd.n640 avss 0.16038f
C2366 avdd.n642 avss 0.01979f
C2367 avdd.n643 avss 0.02698f
C2368 avdd.n644 avss 0.01764f
C2369 avdd.n645 avss 0.01475f
C2370 avdd.n646 avss 0.01475f
C2371 avdd.n647 avss 0.01909f
C2372 avdd.n648 avss 0.01909f
C2373 avdd.n649 avss 0.18532f
C2374 avdd.n650 avss 0.01475f
C2375 avdd.n651 avss 0.16038f
C2376 avdd.n652 avss 0.01475f
C2377 avdd.n653 avss 0.1614f
C2378 avdd.n654 avss 0.21683f
C2379 avdd.n655 avss 0.02694f
C2380 avdd.n656 avss 0.01979f
C2381 avdd.t30 avss 0.20733f
C2382 avdd.n658 avss 0.01979f
C2383 avdd.n659 avss 0.01909f
C2384 avdd.n660 avss 0.06826f
C2385 avdd.n661 avss 0.01171f
C2386 avdd.t2 avss 0.18532f
C2387 avdd.n662 avss 0.01171f
C2388 avdd.n663 avss 0.01171f
C2389 avdd.n664 avss 0.01909f
C2390 avdd.n665 avss 0.01171f
C2391 avdd.n666 avss 0.01171f
C2392 avdd.t3 avss 0.18532f
C2393 avdd.n667 avss 0.01171f
C2394 avdd.n668 avss 0.0676f
C2395 avdd.n669 avss 0.93655f
C2396 avdd.n670 avss 0.07695f
C2397 avdd.n671 avss 0.01909f
C2398 avdd.n672 avss 0.01909f
C2399 avdd.n673 avss 0.18532f
C2400 avdd.n674 avss 0.18532f
C2401 avdd.n675 avss 0.01909f
C2402 avdd.n676 avss 0.01909f
C2403 avdd.n677 avss 0.01475f
C2404 avdd.t66 avss 0.52129f
C2405 avdd.n678 avss 0.05027f
C2406 avdd.t85 avss 0.20733f
C2407 avdd.t86 avss 0.01181f
C2408 avdd.n679 avss 0.15154f
C2409 avdd.n680 avss 0.01979f
C2410 avdd.n681 avss 0.16038f
C2411 avdd.n683 avss 0.01979f
C2412 avdd.n684 avss 0.02698f
C2413 avdd.n685 avss 0.01764f
C2414 avdd.n686 avss 0.01475f
C2415 avdd.n687 avss 0.01475f
C2416 avdd.n688 avss 0.01909f
C2417 avdd.n689 avss 0.01909f
C2418 avdd.n690 avss 0.18532f
C2419 avdd.n691 avss 0.01909f
C2420 avdd.n692 avss 0.01475f
C2421 avdd.n693 avss 0.01475f
C2422 avdd.n694 avss 0.21683f
C2423 avdd.n695 avss 0.16038f
C2424 avdd.n696 avss 0.02694f
C2425 avdd.n697 avss 0.01979f
C2426 avdd.t161 avss 0.20733f
C2427 avdd.n699 avss 0.01979f
C2428 avdd.n700 avss 0.1614f
C2429 avdd.n701 avss 0.06826f
C2430 avdd.n702 avss 0.01171f
C2431 avdd.t64 avss 0.18532f
C2432 avdd.n703 avss 0.01171f
C2433 avdd.n704 avss 0.01171f
C2434 avdd.n705 avss 0.01909f
C2435 avdd.n706 avss 0.01171f
C2436 avdd.n707 avss 0.01171f
C2437 avdd.t65 avss 0.18532f
C2438 avdd.n708 avss 0.01171f
C2439 avdd.n709 avss 0.0676f
C2440 avdd.n710 avss 0.07695f
C2441 avdd.n711 avss 0.01909f
C2442 avdd.n712 avss 0.01909f
C2443 avdd.n713 avss 0.18532f
C2444 avdd.n714 avss 0.18532f
C2445 avdd.n715 avss 0.01909f
C2446 avdd.n716 avss 0.01909f
C2447 avdd.n717 avss 0.01475f
C2448 avdd.t45 avss 0.52225f
C2449 avdd.n718 avss 0.05027f
C2450 avdd.t101 avss 0.20733f
C2451 avdd.t102 avss 0.01181f
C2452 avdd.n719 avss 0.15154f
C2453 avdd.n720 avss 0.01979f
C2454 avdd.n721 avss 0.16038f
C2455 avdd.n723 avss 0.01979f
C2456 avdd.n724 avss 0.02698f
C2457 avdd.n725 avss 0.01764f
C2458 avdd.n726 avss 0.01475f
C2459 avdd.n727 avss 0.01475f
C2460 avdd.n728 avss 0.01909f
C2461 avdd.n729 avss 0.01909f
C2462 avdd.n730 avss 0.18532f
C2463 avdd.n731 avss 0.01475f
C2464 avdd.n732 avss 0.16038f
C2465 avdd.n733 avss 0.01475f
C2466 avdd.n734 avss 0.1614f
C2467 avdd.n735 avss 0.21683f
C2468 avdd.n736 avss 0.02694f
C2469 avdd.n737 avss 0.01979f
C2470 avdd.t5 avss 0.20733f
C2471 avdd.n739 avss 0.01979f
C2472 avdd.n740 avss 0.01909f
C2473 avdd.n741 avss 0.06826f
C2474 avdd.n742 avss 0.01171f
C2475 avdd.t43 avss 0.18532f
C2476 avdd.n743 avss 0.01171f
C2477 avdd.n744 avss 0.01171f
C2478 avdd.n745 avss 0.01909f
C2479 avdd.n746 avss 0.01171f
C2480 avdd.n747 avss 0.01171f
C2481 avdd.t44 avss 0.18532f
C2482 avdd.n748 avss 0.01171f
C2483 avdd.n749 avss 0.0676f
C2484 avdd.n750 avss 0.07695f
C2485 avdd.n751 avss 0.01909f
C2486 avdd.n752 avss 0.01909f
C2487 avdd.n753 avss 0.18532f
C2488 avdd.n754 avss 0.18532f
C2489 avdd.n755 avss 0.01909f
C2490 avdd.n756 avss 0.01909f
C2491 avdd.n757 avss 0.01475f
C2492 avdd.t174 avss 0.0125f
C2493 avdd.n758 avss 0.05027f
C2494 avdd.n759 avss 0.16038f
C2495 avdd.t126 avss 0.01181f
C2496 avdd.n760 avss 0.15154f
C2497 avdd.n761 avss 0.01979f
C2498 avdd.t125 avss 0.20733f
C2499 avdd.n763 avss 0.01979f
C2500 avdd.n764 avss 0.02698f
C2501 avdd.n765 avss 0.01764f
C2502 avdd.n766 avss 0.01475f
C2503 avdd.n767 avss 0.01475f
C2504 avdd.n768 avss 0.01909f
C2505 avdd.n769 avss 0.01909f
C2506 avdd.n770 avss 0.18532f
C2507 avdd.n771 avss 0.01475f
C2508 avdd.n772 avss 0.01475f
C2509 avdd.n773 avss 0.14919f
C2510 avdd.n774 avss 0.163f
C2511 avdd.n775 avss 0.02694f
C2512 avdd.n776 avss 0.01979f
C2513 avdd.n777 avss 0.01979f
C2514 avdd.t22 avss 0.18532f
C2515 avdd.n778 avss 0.01909f
C2516 avdd.n779 avss 0.01909f
C2517 avdd.n780 avss 0.01909f
C2518 avdd.n781 avss 0.06826f
C2519 avdd.n782 avss 0.07695f
C2520 avdd.n783 avss 0.01909f
C2521 avdd.n784 avss 0.01171f
C2522 avdd.n785 avss 0.01909f
C2523 avdd.n786 avss 0.18532f
C2524 avdd.n787 avss 0.18532f
C2525 avdd.n788 avss 0.01909f
C2526 avdd.n789 avss 0.01909f
C2527 avdd.n790 avss 0.01475f
C2528 avdd.t24 avss 0.52239f
C2529 avdd.n791 avss 0.05027f
C2530 avdd.t147 avss 0.20733f
C2531 avdd.t148 avss 0.01181f
C2532 avdd.n792 avss 0.15154f
C2533 avdd.n793 avss 0.01979f
C2534 avdd.n794 avss 0.16038f
C2535 avdd.n796 avss 0.01979f
C2536 avdd.n797 avss 0.02698f
C2537 avdd.n798 avss 0.01764f
C2538 avdd.n799 avss 0.01475f
C2539 avdd.n800 avss 0.01475f
C2540 avdd.n801 avss 0.01171f
C2541 avdd.n802 avss 0.01171f
C2542 avdd.n803 avss 0.01909f
C2543 avdd.n804 avss 0.01171f
C2544 avdd.n805 avss 0.01171f
C2545 avdd.t23 avss 0.18532f
C2546 avdd.n806 avss 0.01171f
C2547 avdd.n807 avss 0.0676f
C2548 avdd.n808 avss 0.01475f
C2549 avdd.n809 avss 0.01475f
C2550 avdd.n810 avss 0.18532f
C2551 avdd.t63 avss 0.20733f
C2552 avdd.n812 avss 0.16038f
C2553 avdd.n813 avss 0.17279f
C2554 avdd.n814 avss 0.4488f
C2555 avdd.n815 avss 0.58089f
C2556 avdd.n816 avss 0.01426f
C2557 avdd.n817 avss 0.01979f
C2558 avdd.t39 avss 0.20733f
C2559 avdd.n819 avss 0.01979f
C2560 avdd.n820 avss 0.01909f
C2561 avdd.n821 avss 0.06826f
C2562 avdd.n822 avss 0.01171f
C2563 avdd.t172 avss 0.18532f
C2564 avdd.n823 avss 0.01171f
C2565 avdd.n824 avss 0.01171f
C2566 avdd.n825 avss 0.01909f
C2567 avdd.n826 avss 0.01171f
C2568 avdd.n827 avss 0.01171f
C2569 avdd.t173 avss 0.18532f
C2570 avdd.n828 avss 0.01171f
C2571 avdd.n829 avss 0.0676f
C2572 avdd.n830 avss 0.93655f
C2573 avdd.n831 avss 0.07695f
C2574 avdd.n832 avss 0.01909f
C2575 avdd.n833 avss 0.01909f
C2576 avdd.n834 avss 0.18532f
C2577 avdd.n835 avss 0.18532f
C2578 avdd.n836 avss 0.01909f
C2579 avdd.n837 avss 0.01909f
C2580 avdd.n838 avss 0.01475f
C2581 avdd.t42 avss 0.0125f
C2582 avdd.n839 avss 0.05027f
C2583 avdd.t99 avss 0.20733f
C2584 avdd.t100 avss 0.01181f
C2585 avdd.n840 avss 0.15154f
C2586 avdd.n841 avss 0.01979f
C2587 avdd.n842 avss 0.16038f
C2588 avdd.n844 avss 0.01979f
C2589 avdd.n845 avss 0.02698f
C2590 avdd.n846 avss 0.01764f
C2591 avdd.n847 avss 0.01475f
C2592 avdd.n848 avss 0.01475f
C2593 avdd.n849 avss 0.01909f
C2594 avdd.n850 avss 0.01909f
C2595 avdd.n851 avss 0.18532f
C2596 avdd.n852 avss 0.01909f
C2597 avdd.n853 avss 0.01475f
C2598 avdd.n854 avss 0.01475f
C2599 avdd.n855 avss 0.21683f
C2600 avdd.n856 avss 0.16038f
C2601 avdd.n857 avss 0.02694f
C2602 avdd.n858 avss 0.01979f
C2603 avdd.t50 avss 0.20733f
C2604 avdd.n860 avss 0.01979f
C2605 avdd.n861 avss 0.1614f
C2606 avdd.n862 avss 0.06826f
C2607 avdd.n863 avss 0.01171f
C2608 avdd.t40 avss 0.18532f
C2609 avdd.n864 avss 0.01171f
C2610 avdd.n865 avss 0.01171f
C2611 avdd.n866 avss 0.01909f
C2612 avdd.n867 avss 0.01171f
C2613 avdd.n868 avss 0.01171f
C2614 avdd.t41 avss 0.18532f
C2615 avdd.n869 avss 0.01171f
C2616 avdd.n870 avss 0.0676f
C2617 avdd.n871 avss 0.07695f
C2618 avdd.n872 avss 0.01909f
C2619 avdd.n873 avss 0.01909f
C2620 avdd.n874 avss 0.18532f
C2621 avdd.n875 avss 0.18532f
C2622 avdd.n876 avss 0.01909f
C2623 avdd.n877 avss 0.01909f
C2624 avdd.n878 avss 0.01475f
C2625 avdd.t155 avss 0.0125f
C2626 avdd.n879 avss 0.05027f
C2627 avdd.t123 avss 0.20733f
C2628 avdd.t124 avss 0.01181f
C2629 avdd.n880 avss 0.15154f
C2630 avdd.n881 avss 0.01979f
C2631 avdd.n882 avss 0.16038f
C2632 avdd.n884 avss 0.01979f
C2633 avdd.n885 avss 0.02698f
C2634 avdd.n886 avss 0.01764f
C2635 avdd.n887 avss 0.01475f
C2636 avdd.n888 avss 0.01475f
C2637 avdd.n889 avss 0.01909f
C2638 avdd.n890 avss 0.01909f
C2639 avdd.n891 avss 0.18532f
C2640 avdd.n892 avss 0.01475f
C2641 avdd.n893 avss 0.16038f
C2642 avdd.n894 avss 0.01475f
C2643 avdd.n895 avss 0.1614f
C2644 avdd.n896 avss 0.21683f
C2645 avdd.n897 avss 0.02694f
C2646 avdd.n898 avss 0.01979f
C2647 avdd.t32 avss 0.20733f
C2648 avdd.n900 avss 0.01979f
C2649 avdd.n901 avss 0.01909f
C2650 avdd.n902 avss 0.06826f
C2651 avdd.n903 avss 0.01171f
C2652 avdd.t153 avss 0.18532f
C2653 avdd.n904 avss 0.01171f
C2654 avdd.n905 avss 0.01171f
C2655 avdd.n906 avss 0.01909f
C2656 avdd.n907 avss 0.01171f
C2657 avdd.n908 avss 0.01171f
C2658 avdd.t154 avss 0.18532f
C2659 avdd.n909 avss 0.01171f
C2660 avdd.n910 avss 0.0676f
C2661 avdd.n911 avss 0.93655f
C2662 avdd.n912 avss 0.07695f
C2663 avdd.n913 avss 0.01909f
C2664 avdd.n914 avss 0.01909f
C2665 avdd.n915 avss 0.18532f
C2666 avdd.n916 avss 0.18532f
C2667 avdd.n917 avss 0.01909f
C2668 avdd.n918 avss 0.01909f
C2669 avdd.n919 avss 0.01475f
C2670 avdd.t35 avss 0.0125f
C2671 avdd.n920 avss 0.05027f
C2672 avdd.t95 avss 0.20733f
C2673 avdd.t96 avss 0.01181f
C2674 avdd.n921 avss 0.15154f
C2675 avdd.n922 avss 0.01979f
C2676 avdd.n923 avss 0.16038f
C2677 avdd.n925 avss 0.01979f
C2678 avdd.n926 avss 0.02698f
C2679 avdd.n927 avss 0.01764f
C2680 avdd.n928 avss 0.01475f
C2681 avdd.n929 avss 0.01475f
C2682 avdd.n930 avss 0.01909f
C2683 avdd.n931 avss 0.01909f
C2684 avdd.n932 avss 0.18532f
C2685 avdd.n933 avss 0.01909f
C2686 avdd.n934 avss 0.01475f
C2687 avdd.n935 avss 0.01475f
C2688 avdd.n936 avss 0.21683f
C2689 avdd.n937 avss 0.16038f
C2690 avdd.n938 avss 0.02694f
C2691 avdd.n939 avss 0.01979f
C2692 avdd.t170 avss 0.20733f
C2693 avdd.n941 avss 0.01979f
C2694 avdd.n942 avss 0.1614f
C2695 avdd.n943 avss 0.06826f
C2696 avdd.n944 avss 0.01171f
C2697 avdd.t33 avss 0.18532f
C2698 avdd.n945 avss 0.01171f
C2699 avdd.n946 avss 0.01171f
C2700 avdd.n947 avss 0.01909f
C2701 avdd.n948 avss 0.01171f
C2702 avdd.n949 avss 0.01171f
C2703 avdd.t34 avss 0.18532f
C2704 avdd.n950 avss 0.01171f
C2705 avdd.n951 avss 0.0676f
C2706 avdd.n952 avss 0.07695f
C2707 avdd.n953 avss 0.01909f
C2708 avdd.n954 avss 0.01909f
C2709 avdd.n955 avss 0.18532f
C2710 avdd.n956 avss 0.18532f
C2711 avdd.n957 avss 0.01909f
C2712 avdd.n958 avss 0.01909f
C2713 avdd.n959 avss 0.01475f
C2714 avdd.t21 avss 0.0125f
C2715 avdd.n960 avss 0.05027f
C2716 avdd.t91 avss 0.20733f
C2717 avdd.t92 avss 0.01181f
C2718 avdd.n961 avss 0.15154f
C2719 avdd.n962 avss 0.01979f
C2720 avdd.n963 avss 0.16038f
C2721 avdd.n965 avss 0.01979f
C2722 avdd.n966 avss 0.02698f
C2723 avdd.n967 avss 0.01764f
C2724 avdd.n968 avss 0.01475f
C2725 avdd.n969 avss 0.01475f
C2726 avdd.n970 avss 0.01909f
C2727 avdd.n971 avss 0.01909f
C2728 avdd.n972 avss 0.18532f
C2729 avdd.n973 avss 0.01909f
C2730 avdd.n974 avss 0.01475f
C2731 avdd.n975 avss 0.01475f
C2732 avdd.n976 avss 0.21683f
C2733 avdd.n977 avss 0.16038f
C2734 avdd.n978 avss 0.02694f
C2735 avdd.n979 avss 0.01979f
C2736 avdd.t27 avss 0.20733f
C2737 avdd.n981 avss 0.01979f
C2738 avdd.n982 avss 0.1614f
C2739 avdd.n983 avss 0.06826f
C2740 avdd.n984 avss 0.01171f
C2741 avdd.t19 avss 0.18532f
C2742 avdd.n985 avss 0.01171f
C2743 avdd.n986 avss 0.01171f
C2744 avdd.n987 avss 0.01909f
C2745 avdd.n988 avss 0.01171f
C2746 avdd.n989 avss 0.01171f
C2747 avdd.t20 avss 0.18532f
C2748 avdd.n990 avss 0.01171f
C2749 avdd.n991 avss 0.0676f
C2750 avdd.n992 avss 0.07695f
C2751 avdd.n993 avss 0.01909f
C2752 avdd.n994 avss 0.01171f
C2753 avdd.n995 avss 0.01909f
C2754 avdd.n996 avss 0.18532f
C2755 avdd.n997 avss 0.18532f
C2756 avdd.n998 avss 0.01909f
C2757 avdd.n999 avss 0.01909f
C2758 avdd.n1000 avss 0.01475f
C2759 avdd.t18 avss 0.0125f
C2760 avdd.n1001 avss 0.05027f
C2761 avdd.t77 avss 0.20733f
C2762 avdd.t78 avss 0.01181f
C2763 avdd.n1002 avss 0.15154f
C2764 avdd.n1003 avss 0.01979f
C2765 avdd.n1004 avss 0.16038f
C2766 avdd.n1006 avss 0.01979f
C2767 avdd.n1007 avss 0.02698f
C2768 avdd.n1008 avss 0.01764f
C2769 avdd.n1009 avss 0.01475f
C2770 avdd.n1010 avss 0.01475f
C2771 avdd.n1011 avss 0.01171f
C2772 avdd.n1012 avss 0.01171f
C2773 avdd.n1013 avss 0.01909f
C2774 avdd.n1014 avss 0.01171f
C2775 avdd.n1015 avss 0.01171f
C2776 avdd.t17 avss 0.18532f
C2777 avdd.n1016 avss 0.01171f
C2778 avdd.n1017 avss 0.0676f
C2779 avdd.n1018 avss 0.07695f
C2780 avdd.n1019 avss 0.01909f
C2781 avdd.n1020 avss 0.01909f
C2782 avdd.n1021 avss 0.18532f
C2783 avdd.n1022 avss 0.18532f
C2784 avdd.n1023 avss 0.01909f
C2785 avdd.n1024 avss 0.01909f
C2786 avdd.n1025 avss 0.01475f
C2787 avdd.t135 avss 0.0125f
C2788 avdd.n1026 avss 0.05027f
C2789 avdd.n1027 avss 0.16038f
C2790 avdd.t120 avss 0.01181f
C2791 avdd.n1028 avss 0.15154f
C2792 avdd.n1029 avss 0.01979f
C2793 avdd.t119 avss 0.20733f
C2794 avdd.n1031 avss 0.01979f
C2795 avdd.n1032 avss 0.02698f
C2796 avdd.n1033 avss 0.01764f
C2797 avdd.n1034 avss 0.01475f
C2798 avdd.n1035 avss 0.01475f
C2799 avdd.n1036 avss 0.01909f
C2800 avdd.n1037 avss 0.01909f
C2801 avdd.n1038 avss 0.18532f
C2802 avdd.n1039 avss 0.01475f
C2803 avdd.n1040 avss 0.01475f
C2804 avdd.n1041 avss 0.14919f
C2805 avdd.n1042 avss 0.163f
C2806 avdd.n1043 avss 0.02694f
C2807 avdd.n1044 avss 0.01979f
C2808 avdd.n1045 avss 0.01979f
C2809 avdd.t67 avss 0.18532f
C2810 avdd.n1046 avss 0.01909f
C2811 avdd.n1047 avss 0.01909f
C2812 avdd.n1048 avss 0.01909f
C2813 avdd.n1049 avss 0.06826f
C2814 avdd.n1050 avss 0.07695f
C2815 avdd.n1051 avss 0.01909f
C2816 avdd.n1052 avss 0.01171f
C2817 avdd.n1053 avss 0.01909f
C2818 avdd.n1054 avss 0.18532f
C2819 avdd.n1055 avss 0.18532f
C2820 avdd.n1056 avss 0.01909f
C2821 avdd.n1057 avss 0.01909f
C2822 avdd.n1058 avss 0.01475f
C2823 avdd.t69 avss 0.0125f
C2824 avdd.n1059 avss 0.05027f
C2825 avdd.t145 avss 0.20733f
C2826 avdd.t146 avss 0.01181f
C2827 avdd.n1060 avss 0.15154f
C2828 avdd.n1061 avss 0.01979f
C2829 avdd.n1062 avss 0.16038f
C2830 avdd.n1064 avss 0.01979f
C2831 avdd.n1065 avss 0.02698f
C2832 avdd.n1066 avss 0.01764f
C2833 avdd.n1067 avss 0.01475f
C2834 avdd.n1068 avss 0.01475f
C2835 avdd.n1069 avss 0.01171f
C2836 avdd.n1070 avss 0.01171f
C2837 avdd.n1071 avss 0.01909f
C2838 avdd.n1072 avss 0.01171f
C2839 avdd.n1073 avss 0.01171f
C2840 avdd.t68 avss 0.18532f
C2841 avdd.n1074 avss 0.01171f
C2842 avdd.n1075 avss 0.0676f
C2843 avdd.n1076 avss 0.01475f
C2844 avdd.n1077 avss 0.01475f
C2845 avdd.n1078 avss 0.18532f
C2846 avdd.t25 avss 0.20733f
C2847 avdd.n1080 avss 0.16038f
C2848 avdd.n1081 avss 0.17279f
C2849 avdd.n1082 avss 0.4488f
C2850 avdd.n1083 avss 0.58089f
C2851 avdd.n1084 avss 0.01426f
C2852 avdd.n1085 avss 0.01979f
C2853 avdd.t62 avss 0.20733f
C2854 avdd.n1087 avss 0.01979f
C2855 avdd.n1088 avss 0.01909f
C2856 avdd.n1089 avss 0.06826f
C2857 avdd.n1090 avss 0.01171f
C2858 avdd.t133 avss 0.18532f
C2859 avdd.n1091 avss 0.01171f
C2860 avdd.n1092 avss 0.01171f
C2861 avdd.n1093 avss 0.01909f
C2862 avdd.n1094 avss 0.01171f
C2863 avdd.n1095 avss 0.01171f
C2864 avdd.t134 avss 0.18532f
C2865 avdd.n1096 avss 0.01171f
C2866 avdd.n1097 avss 0.0676f
C2867 avdd.n1098 avss 0.93655f
C2868 avdd.n1099 avss 0.01475f
C2869 avdd.n1100 avss 0.01475f
C2870 avdd.n1101 avss 0.18532f
C2871 avdd.t166 avss 0.20733f
C2872 avdd.n1103 avss 0.16038f
C2873 avdd.n1104 avss 0.17279f
C2874 avdd.n1105 avss 0.49861f
C2875 avdd.n1106 avss 0.58408f
C2876 avdd.t181 avss 0.20733f
C2877 avdd.n1107 avss 0.1206f
C2878 avdd.n1108 avss 0.01979f
C2879 avdd.t182 avss 0.01189f
C2880 avdd.n1109 avss 0.06207f
C2881 avdd.n1110 avss 0.16038f
C2882 avdd.n1112 avss 0.01979f
C2883 avdd.n1113 avss 0.01856f
C2884 avdd.n1114 avss 0.01764f
C2885 avdd.n1115 avss 0.01171f
C2886 avdd.n1116 avss 0.01171f
C2887 avdd.t168 avss 0.18532f
C2888 avdd.n1117 avss 0.01171f
C2889 avdd.n1118 avss 0.0676f
C2890 avdd.n1119 avss 0.06694f
C2891 avdd.n1120 avss 0.01171f
C2892 avdd.t167 avss 0.18532f
C2893 avdd.n1121 avss 0.01171f
C2894 avdd.n1122 avss 0.01189f
C2895 avdd.n1123 avss 0.01876f
C2896 avdd.n1124 avss 0.02431f
C2897 avdd.n1125 avss 0.01979f
C2898 avdd.t130 avss 0.20733f
C2899 avdd.n1127 avss 0.01979f
C2900 avdd.n1128 avss 0.62433f
C2901 avdd.n1129 avss 0.01972f
C2902 avdd.t56 avss 0.64513f
C2903 avdd.n1130 avss 0.01045f
C2904 avdd.n1131 avss 0.01045f
C2905 avdd.n1132 avss 0.02746f
C2906 avdd.n1133 avss 0.01972f
C2907 avdd.n1134 avss 0.21683f
C2908 avdd.n1135 avss 0.01972f
C2909 avdd.n1136 avss 0.02631f
C2910 avdd.n1137 avss 0.01922f
C2911 avdd.n1138 avss 0.01972f
C2912 avdd.n1139 avss 0.01045f
C2913 avdd.n1140 avss 0.01922f
C2914 avdd.n1141 avss 0.01601f
C2915 avdd.n1142 avss 0.01972f
C2916 avdd.n1143 avss 0.06826f
C2917 avdd.n1144 avss 0.07695f
C2918 avdd.n1145 avss 0.01972f
C2919 avdd.n1146 avss 0.01601f
C2920 avdd.n1147 avss 0.01538f
C2921 avdd.n1148 avss 0.01972f
C2922 avdd.t140 avss 0.37279f
C2923 avdd.n1149 avss 0.02635f
C2924 avdd.n1150 avss 0.01827f
C2925 avdd.n1151 avss 0.01045f
C2926 avdd.n1152 avss 0.01045f
C2927 avdd.n1153 avss 0.48086f
C2928 avdd.n1154 avss 0.01045f
C2929 avdd.n1155 avss 0.01972f
C2930 avdd.n1156 avss 0.01601f
C2931 avdd.n1157 avss 0.01538f
C2932 avdd.n1158 avss 0.1614f
C2933 avdd.n1159 avss 0.01922f
C2934 avdd.n1160 avss 0.48086f
C2935 avdd.n1161 avss 0.01922f
C2936 avdd.n1162 avss 0.0883f
C2937 avdd.t7 avss 0.18532f
C2938 avdd.n1163 avss 0.01171f
C2939 avdd.n1164 avss 0.0676f
C2940 avdd.n1165 avss 0.07695f
C2941 avdd.n1166 avss 0.06826f
C2942 avdd.n1167 avss 0.01171f
C2943 avdd.t139 avss 0.18532f
C2944 avdd.n1168 avss 0.01171f
C2945 avdd.n1169 avss 0.01171f
C2946 avdd.n1170 avss 0.01909f
C2947 avdd.n1171 avss 0.01171f
C2948 avdd.n1172 avss 0.01764f
C2949 avdd.n1173 avss 0.05027f
C2950 avdd.n1174 avss 0.01475f
C2951 avdd.n1175 avss 0.01909f
C2952 avdd.n1176 avss 0.01979f
C2953 avdd.t179 avss 0.20733f
C2954 avdd.n1178 avss 0.01979f
C2955 avdd.n1179 avss 0.25149f
C2956 avdd.n1180 avss 0.47503f
C2957 avdd.n1181 avss 0.35354f
C2958 avdd.t49 avss 0.20733f
C2959 avdd.n1182 avss 0.01979f
C2960 avdd.n1183 avss 0.15077f
C2961 avdd.n1184 avss 0.16038f
C2962 avdd.n1186 avss 0.01979f
C2963 avdd.n1187 avss 0.08741f
C2964 avdd.n1188 avss 0.01475f
C2965 avdd.n1189 avss 0.01475f
C2966 avdd.n1190 avss 0.01909f
C2967 avdd.n1191 avss 0.01171f
C2968 avdd.n1192 avss 0.01171f
C2969 avdd.t36 avss 0.18532f
C2970 avdd.n1193 avss 0.01171f
C2971 avdd.n1194 avss 0.01909f
C2972 avdd.n1195 avss 0.01171f
C2973 avdd.t136 avss 0.18532f
C2974 avdd.n1196 avss 0.01171f
C2975 avdd.n1197 avss 0.01171f
C2976 avdd.n1198 avss 0.01764f
C2977 avdd.n1199 avss 0.02698f
C2978 avdd.n1200 avss 0.01979f
C2979 avdd.t93 avss 0.20733f
C2980 avdd.n1202 avss 0.01979f
C2981 avdd.n1203 avss 0.15154f
C2982 avdd.n1204 avss 0.0676f
C2983 avdd.t54 avss 0.05505f
C2984 avdd.n1205 avss 0.05027f
C2985 avdd.n1206 avss 0.23461f
C2986 avdd.n1207 avss 0.01909f
C2987 avdd.t90 avss 0.01241f
C2988 avdd.n1208 avss 0.04874f
C2989 avdd.n1209 avss 0.16038f
C2990 avdd.n1210 avss 0.18532f
C2991 avdd.n1211 avss 0.01475f
C2992 avdd.n1212 avss 0.01909f
C2993 avdd.n1213 avss 0.01909f
C2994 avdd.n1214 avss 0.01909f
C2995 avdd.n1215 avss 0.18532f
C2996 avdd.n1216 avss 0.01475f
C2997 avdd.n1217 avss 0.01909f
C2998 avdd.n1218 avss 0.01475f
C2999 avdd.n1219 avss 0.07695f
C3000 avdd.n1220 avss 0.06826f
C3001 avdd.n1221 avss 0.18532f
C3002 avdd.n1222 avss 0.01909f
C3003 avdd.n1223 avss 0.01475f
C3004 avdd.n1224 avss 0.22961f
C3005 avdd.n1225 avss 0.16038f
C3006 avdd.n1226 avss 0.15139f
C3007 avdd.n1227 avss 0.01979f
C3008 avdd.t26 avss 0.20733f
C3009 avdd.n1229 avss 0.01979f
C3010 avdd.n1230 avss 0.02416f
C3011 avdd.n1231 avss 0.01909f
C3012 avdd.n1232 avss 0.01171f
C3013 avdd.n1233 avss 0.01171f
C3014 avdd.t46 avss 0.18532f
C3015 avdd.n1234 avss 0.01171f
C3016 avdd.n1235 avss 0.01909f
C3017 avdd.n1236 avss 0.01171f
C3018 avdd.t53 avss 0.18532f
C3019 avdd.n1237 avss 0.01171f
C3020 avdd.n1238 avss 0.01171f
C3021 avdd.n1239 avss 0.01764f
C3022 avdd.n1240 avss 0.02096f
C3023 avdd.n1241 avss 0.01979f
C3024 avdd.t89 avss 0.20733f
C3025 avdd.n1243 avss 0.01979f
C3026 avdd.n1244 avss 0.13706f
C3027 avdd.n1245 avss 0.0676f
C3028 avdd.t176 avss 0.1053f
C3029 avdd.n1246 avss 0.23461f
C3030 avdd.n1247 avss 0.01909f
C3031 avdd.t114 avss 0.06114f
C3032 avdd.n1248 avss 0.16038f
C3033 avdd.n1249 avss 0.18532f
C3034 avdd.n1250 avss 0.01475f
C3035 avdd.n1251 avss 0.01909f
C3036 avdd.n1252 avss 0.01909f
C3037 avdd.n1253 avss 0.01909f
C3038 avdd.n1254 avss 0.18532f
C3039 avdd.n1255 avss 0.01475f
C3040 avdd.n1256 avss 0.01909f
C3041 avdd.n1257 avss 0.01475f
C3042 avdd.n1258 avss 0.07695f
C3043 avdd.n1259 avss 0.06826f
C3044 avdd.n1260 avss 0.18532f
C3045 avdd.n1261 avss 0.01909f
C3046 avdd.n1262 avss 0.01475f
C3047 avdd.n1263 avss 0.22961f
C3048 avdd.n1264 avss 0.16038f
C3049 avdd.n1265 avss 0.15139f
C3050 avdd.n1266 avss 0.01979f
C3051 avdd.t162 avss 0.20733f
C3052 avdd.n1268 avss 0.01979f
C3053 avdd.n1269 avss 0.02416f
C3054 avdd.n1270 avss 0.01909f
C3055 avdd.n1271 avss 0.01171f
C3056 avdd.n1272 avss 0.01171f
C3057 avdd.t51 avss 0.18532f
C3058 avdd.n1273 avss 0.01171f
C3059 avdd.n1274 avss 0.01909f
C3060 avdd.n1275 avss 0.01171f
C3061 avdd.t175 avss 0.18532f
C3062 avdd.n1276 avss 0.01171f
C3063 avdd.n1277 avss 0.01171f
C3064 avdd.n1278 avss 0.01764f
C3065 avdd.n1279 avss 0.02096f
C3066 avdd.n1280 avss 0.01979f
C3067 avdd.t113 avss 0.20733f
C3068 avdd.n1282 avss 0.01979f
C3069 avdd.n1283 avss 0.13706f
C3070 avdd.n1284 avss 0.93655f
C3071 avdd.n1285 avss 0.0676f
C3072 avdd.t71 avss 0.10538f
C3073 avdd.n1286 avss 0.23461f
C3074 avdd.n1287 avss 0.01909f
C3075 avdd.t88 avss 0.06114f
C3076 avdd.n1288 avss 0.16038f
C3077 avdd.n1289 avss 0.18532f
C3078 avdd.n1290 avss 0.01475f
C3079 avdd.n1291 avss 0.01909f
C3080 avdd.n1292 avss 0.01909f
C3081 avdd.n1293 avss 0.01909f
C3082 avdd.n1294 avss 0.18532f
C3083 avdd.n1295 avss 0.01475f
C3084 avdd.n1296 avss 0.01909f
C3085 avdd.n1297 avss 0.01475f
C3086 avdd.n1298 avss 0.07695f
C3087 avdd.n1299 avss 0.18532f
C3088 avdd.n1300 avss 0.01909f
C3089 avdd.n1301 avss 0.01475f
C3090 avdd.n1302 avss 0.22961f
C3091 avdd.n1303 avss 0.16038f
C3092 avdd.n1304 avss 0.15139f
C3093 avdd.n1305 avss 0.01979f
C3094 avdd.t108 avss 0.20733f
C3095 avdd.n1307 avss 0.01979f
C3096 avdd.n1308 avss 0.02416f
C3097 avdd.n1309 avss 0.01909f
C3098 avdd.n1310 avss 0.01171f
C3099 avdd.n1311 avss 0.01171f
C3100 avdd.t129 avss 0.18532f
C3101 avdd.n1312 avss 0.01171f
C3102 avdd.n1313 avss 0.01909f
C3103 avdd.n1314 avss 0.01171f
C3104 avdd.t70 avss 0.18532f
C3105 avdd.n1315 avss 0.01171f
C3106 avdd.n1316 avss 0.01171f
C3107 avdd.n1317 avss 0.01764f
C3108 avdd.n1318 avss 0.02096f
C3109 avdd.n1319 avss 0.01979f
C3110 avdd.t87 avss 0.20733f
C3111 avdd.n1321 avss 0.01979f
C3112 avdd.n1322 avss 0.13706f
C3113 avdd.n1323 avss 0.07695f
C3114 avdd.n1324 avss 0.01909f
C3115 avdd.n1325 avss 0.01909f
C3116 avdd.n1326 avss 0.18532f
C3117 avdd.n1327 avss 0.18532f
C3118 avdd.n1328 avss 0.01909f
C3119 avdd.n1329 avss 0.01909f
C3120 avdd.n1330 avss 0.01475f
C3121 avdd.n1331 avss 0.01475f
C3122 avdd.n1332 avss 0.22684f
C3123 avdd.n1333 avss 0.16038f
C3124 avdd.n1334 avss 0.15139f
C3125 avdd.n1335 avss 0.01979f
C3126 avdd.t55 avss 0.20733f
C3127 avdd.n1337 avss 0.01979f
C3128 avdd.n1338 avss 0.02694f
C3129 avdd.n1339 avss 0.01909f
C3130 avdd.n1340 avss 0.01475f
C3131 avdd.n1341 avss 0.01475f
C3132 avdd.n1342 avss 0.01764f
C3133 avdd.n1343 avss 0.01909f
C3134 avdd.n1344 avss 0.18532f
C3135 avdd.n1345 avss 0.01909f
C3136 avdd.n1346 avss 0.01475f
C3137 avdd.t160 avss 0.10531f
C3138 avdd.n1347 avss 0.02698f
C3139 avdd.n1348 avss 0.01979f
C3140 avdd.t79 avss 0.20733f
C3141 avdd.n1350 avss 0.01979f
C3142 avdd.n1351 avss 0.15154f
C3143 avdd.n1352 avss 0.0676f
C3144 avdd.n1353 avss 0.01171f
C3145 avdd.t159 avss 0.18532f
C3146 avdd.n1354 avss 0.01171f
C3147 avdd.n1355 avss 0.01171f
C3148 avdd.n1356 avss 0.01909f
C3149 avdd.n1357 avss 0.01171f
C3150 avdd.n1358 avss 0.01171f
C3151 avdd.t72 avss 0.18532f
C3152 avdd.n1359 avss 0.01171f
C3153 avdd.n1360 avss 0.06826f
.ends

** sch_path: /foss/designs/crossmem_ipn/designs/libs/crossmem_ipn/dac5bits/sch/sw.sch
.subckt sw avdd b_in avss vin1 vout vin2
*.PININFO avss:B vin1:B vout:B avdd:B vin2:B b_in:B
XM1 net1 b_in avss avss sky130_fd_pr__nfet_01v8 L=0.15 W=0.5 nf=1
XM2 net1 b_in avdd avdd sky130_fd_pr__pfet_01v8 L=0.15 W=0.5 nf=1
XM3 net2 net1 avss avss sky130_fd_pr__nfet_01v8 L=0.15 W=0.5 nf=1
XM4 net2 net1 avdd avdd sky130_fd_pr__pfet_01v8 L=0.15 W=0.5 nf=1
XM5 vout net1 vin1 avdd sky130_fd_pr__pfet_01v8 L=0.15 W=0.5 nf=1
XM6 vout net1 vin2 avss sky130_fd_pr__nfet_01v8 L=0.15 W=0.5 nf=1
XM7 vin1 net2 vout avss sky130_fd_pr__nfet_01v8 L=0.15 W=0.5 nf=1
XM8 vin2 net2 vout avdd sky130_fd_pr__pfet_01v8 L=0.15 W=0.5 nf=1
.ends
